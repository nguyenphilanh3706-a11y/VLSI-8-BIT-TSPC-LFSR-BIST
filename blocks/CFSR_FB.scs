// Hoi tiep day du (CFSR): FB = Q0 ^ Q5 ^ Q6 ^ Q7 ^ NOR(Q0..Q6).
// Them nhanh NOR dua trang thai toan 0 vao chuoi: 255 -> 256 trang thai.
simulator lang=spectre
subckt CFSR_FB Q0 Q1 Q2 Q3 Q4 Q5 Q6 Q7 FB VDD VSS
I0 (Q0 Q5 Q6 Q7 tap VDD VSS) XORTAP8
I1 (Q0 Q1 n01 VDD VSS) NOR2_X1
I2 (Q2 Q3 n23 VDD VSS) NOR2_X1
I3 (Q4 Q5 n45 VDD VSS) NOR2_X1
I4 (Q6 q6n VDD VSS) INV_X1
I5 (n01 n23 a VDD VSS) NAND2_X1
I6 (n45 q6n b VDD VSS) NAND2_X1
I7 (a b z VDD VSS) NOR2_X1
I8 (tap z FB VDD VSS) XOR2_X1
ends CFSR_FB
