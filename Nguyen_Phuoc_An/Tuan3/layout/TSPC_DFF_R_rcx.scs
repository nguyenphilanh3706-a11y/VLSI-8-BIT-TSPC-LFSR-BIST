// TSPC_DFF_R sau layout: Assura RCX
simulator lang=spectre
subckt TSPC_DFF_R D CLK RST Q QB VDD GND
    I_M3 (X_3 D_4 GND GND) gpdk090_nmos1v w=0.24u l=0.1u ad=0.0984p as=0.0696p pd=1.3u ps=0.82u
    I_MRN (Y_7 RST_4 GND GND) gpdk090_nmos1v w=0.24u l=0.1u ad=0.0984p as=0.0696p pd=1.3u ps=0.82u
    I_M4 (Y_5 X_7 n4 GND) gpdk090_nmos1v w=0.48u l=0.1u ad=0.1968p as=0.1392p pd=1.78u ps=1.06u
    I_M5 (n4 CLK_9 GND GND) gpdk090_nmos1v w=0.48u l=0.1u ad=0.1392p as=0.1968p pd=1.06u ps=1.78u
    I_M8 (n7 Y_11 GND GND) gpdk090_nmos1v w=0.24u l=0.1u ad=0.0696p as=0.0984p pd=0.82u ps=1.3u
    I_M7 (QB_8 CLK_12 n7 GND) gpdk090_nmos1v w=0.24u l=0.1u ad=0.0984p as=0.0696p pd=1.3u ps=0.82u
    I_MN (Q_6 QB_13 GND GND) gpdk090_nmos1v w=0.24u l=0.1u ad=0.0984p as=0.0984p pd=1.3u ps=1.3u
    I_M2 (X CLK_3 pa VDD) gpdk090_pmos1v w=0.48u l=0.1u ad=0.1968p as=0.1392p pd=1.78u ps=1.06u
    I_M1 (pa D_2 VDD VDD) gpdk090_pmos1v w=0.48u l=0.1u ad=0.1392p as=0.1392p pd=1.06u ps=1.06u
    I_MRP (pm RST_2 VDD VDD) gpdk090_pmos1v w=0.48u l=0.1u ad=0.1392p as=0.1392p pd=1.06u ps=1.06u
    I_M6 (Y_2 CLK_6 pm VDD) gpdk090_pmos1v w=0.48u l=0.1u ad=0.1968p as=0.1392p pd=1.78u ps=1.06u
    I_MKY (Y QB_3 VDD VDD) gpdk090_pmos1v w=0.12u l=0.4u ad=0.078p as=0.1086p pd=1.3u ps=1.06u
    I_M9 (QB_7 Y_10 VDD VDD) gpdk090_pmos1v w=0.48u l=0.1u ad=0.1968p as=0.1086p pd=1.78u ps=1.06u
    I_MKQ (QB_5 Q_3 VDD VDD) gpdk090_pmos1v w=0.12u l=0.4u ad=0.078p as=0.1086p pd=1.3u ps=1.06u
    I_MP (Q_4 QB_12 VDD VDD) gpdk090_pmos1v w=0.48u l=0.1u ad=0.1968p as=0.1086p pd=1.78u ps=1.06u
    I_Rj1 (CLK_3 CLK_2) resistor r=16.5435
    I_Rj2 (D_2 D_3) resistor r=28.5435
    I_Rj3 (D_3 D_4) resistor r=44.5435
    I_Rj4 (D D_3) resistor r=10.0000
    I_Rj5 (RST_2 RST_3) resistor r=28.5435
    I_Rj6 (RST_3 RST_4) resistor r=44.5435
    I_Rj7 (RST RST_3) resistor r=10.0000
    I_Rj8 (CLK_6 CLK_5) resistor r=16.5435
    I_Rj9 (X_7 X_5) resistor r=16.5435
    I_Rj10 (CLK_9 CLK) resistor r=52.5435
    I_Rj11 (QB_1 QB_3) resistor r=52.2934
    I_Rj12 (Y_10 Y_9) resistor r=28.5435
    I_Rj13 (Y_9 Y_11) resistor r=44.5435
    I_Rj14 (CLK_12 CLK_11) resistor r=54.5435
    I_Rj15 (Q_2 Q_3) resistor r=24.2934
    I_Rj16 (QB_12 QB_9) resistor r=44.5435
    I_Rj17 (QB_9 QB_13) resistor r=28.5435
    I_Ri1 (X X_2) resistor r=16.7081
    I_Ri2 (CLK_1 CLK_2) resistor r=11.6192
    I_Ri3 (X_3 X_4) resistor r=16.8414
    I_Ri8 (CLK_4 CLK_5) resistor r=11.6192
    I_Ri9 (X_5 X_6) resistor r=11.4913
    I_Ri10 (CLK_7 CLK) resistor r=1.6059
    I_Ri13 (Y Y_3) resistor r=15.9152
    I_Ri15 (Y_3 Y_6) resistor r=0.7054
    I_Ri16 (Y_6 Y_7) resistor r=15.4200
    I_Ri17 (Y_2 Y_3) resistor r=15.0000
    I_Ri18 (Y_5 Y_6) resistor r=15.0000
    I_Ri19 (QB_1 QB_2) resistor r=11.4913
    I_Ri20 (Y_8 Y_9) resistor r=11.6592
    I_Ri21 (CLK_10 CLK_11) resistor r=11.6059
    I_Ri22 (QB QB_4) resistor r=0.2814
    I_Ri23 (QB_4 QB_6) resistor r=0.3081
    I_Ri24 (QB_6 QB_7) resistor r=15.4200
    I_Ri25 (QB QB_8) resistor r=15.1600
    I_Ri26 (QB_5 QB_6) resistor r=15.0000
    I_Ri27 (Q_1 Q_2) resistor r=11.6192
    I_Ri28 (QB_9 QB_10) resistor r=11.4913
    I_Ri29 (Q_4 Q_5) resistor r=15.5152
    I_Ri30 (Q_5 Q) resistor r=3.333E-02
    I_Ri31 (Q Q_6) resistor r=15.1600
    I_Rh1 (X_6 X_4) resistor r=0.9520
    I_Rh2 (X_4 X_2) resistor r=0.2720
    I_Rh3 (Y_8 Y_3) resistor r=2.4720
    I_Rh4 (CLK_10 CLK_7) resistor r=0.9360
    I_Rh5 (CLK_7 CLK_4) resistor r=0.5440
    I_Rh6 (CLK_4 CLK_1) resistor r=0.8160
    I_Rh7 (QB_10 QB_11) resistor r=0.5280
    I_Rh8 (QB_11 QB_2) resistor r=0.7400
    I_Rh9 (QB_4 QB_11) resistor r=1.4000
    I_Rh10 (Q_5 Q_1) resistor r=1.8680
    I_C1 (VDD GND) capacitor c=1.059E-15
    I_C2 (CLK GND) capacitor c=8.430E-17
    I_C3 (D GND) capacitor c=1.411E-16
    I_C4 (Q GND) capacitor c=1.152E-16
    I_C5 (QB GND) capacitor c=5.212E-17
    I_C6 (RST GND) capacitor c=1.042E-16
    I_C7 (n4 GND) capacitor c=4.277E-18
    I_C8 (Y GND) capacitor c=7.096E-17
    I_C9 (X GND) capacitor c=2.166E-17
    I_C10 (CLK_3 GND) capacitor c=4.397E-17
    I_C11 (D_2 GND) capacitor c=4.624E-17
    I_C12 (RST_2 GND) capacitor c=4.691E-17
    I_C13 (CLK_6 GND) capacitor c=4.718E-17
    I_C14 (QB_3 GND) capacitor c=7.722E-17
    I_C15 (Y_10 GND) capacitor c=5.684E-17
    I_C16 (Q_3 GND) capacitor c=5.397E-17
    I_C17 (QB_12 GND) capacitor c=6.527E-17
    I_C18 (D_4 GND) capacitor c=5.727E-17
    I_C19 (RST_4 GND) capacitor c=5.110E-17
    I_C20 (X_7 GND) capacitor c=4.482E-17
    I_C21 (CLK_9 GND) capacitor c=4.772E-17
    I_C22 (Y_11 GND) capacitor c=4.723E-17
    I_C23 (CLK_12 GND) capacitor c=4.815E-17
    I_C24 (QB_13 GND) capacitor c=5.042E-17
    I_C25 (CLK_2 GND) capacitor c=1.122E-16
    I_C26 (CLK_5 GND) capacitor c=7.519E-17
    I_C27 (X_5 GND) capacitor c=7.047E-17
    I_C28 (QB_1 GND) capacitor c=7.835E-17
    I_C29 (Y_9 GND) capacitor c=9.815E-17
    I_C30 (CLK_11 GND) capacitor c=1.060E-16
    I_C31 (Q_2 GND) capacitor c=9.384E-17
    I_C32 (QB_9 GND) capacitor c=8.926E-17
    I_C33 (X_2 GND) capacitor c=1.215E-16
    I_C34 (CLK_1 GND) capacitor c=2.063E-16
    I_C35 (X_4 GND) capacitor c=2.933E-16
    I_C36 (CLK_4 GND) capacitor c=2.643E-16
    I_C37 (X_6 GND) capacitor c=2.341E-16
    I_C38 (CLK_7 GND) capacitor c=1.948E-16
    I_C39 (QB_2 GND) capacitor c=1.903E-16
    I_C40 (Y_8 GND) capacitor c=2.062E-16
    I_C41 (CLK_10 GND) capacitor c=2.021E-16
    I_C42 (QB_4 GND) capacitor c=2.199E-16
    I_C43 (Q_1 GND) capacitor c=1.359E-16
    I_C44 (QB_10 GND) capacitor c=1.474E-16
    I_C45 (Q_5 GND) capacitor c=5.915E-17
    I_C46 (Y_2 GND) capacitor c=8.711E-19
    I_C47 (QB_7 GND) capacitor c=6.852E-17
    I_C48 (QB_5 GND) capacitor c=5.188E-17
    I_C49 (Q_4 GND) capacitor c=4.322E-17
    I_C50 (X_3 GND) capacitor c=5.579E-17
    I_C51 (Y_7 GND) capacitor c=6.298E-17
    I_C52 (Y_5 GND) capacitor c=1.156E-16
    I_C53 (QB_8 GND) capacitor c=2.395E-17
    I_C54 (Q_6 GND) capacitor c=2.148E-17
    I_C55 (Y_3 GND) capacitor c=2.619E-16
ends TSPC_DFF_R
