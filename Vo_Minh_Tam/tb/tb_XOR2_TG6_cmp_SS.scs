// XOR2_TG6 so sanh, corner SS
simulator lang=spectre
include "/home/buet/cadence/gpdk090_v4.6/models/spectre/gpdk090.scs" section=SS
include "../cells/cells.scs"
include "../cells/XOR2_TG/XOR2_TG.scs"
include "tb_XOR2_TG6_cmp.scs"
