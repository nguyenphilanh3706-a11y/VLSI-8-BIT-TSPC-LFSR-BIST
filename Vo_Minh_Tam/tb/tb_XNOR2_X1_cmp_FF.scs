// XNOR2_X1 so sanh, corner FF
simulator lang=spectre
include "/home/buet/cadence/gpdk090_v4.6/models/spectre/gpdk090.scs" section=FF
include "../cells/cells.scs"
include "../cells/XOR2_TG/XOR2_TG.scs"
include "tb_XNOR2_X1_cmp.scs"
