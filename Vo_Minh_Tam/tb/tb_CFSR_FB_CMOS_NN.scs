// CFSR_FB_CMOS, corner NN
simulator lang=spectre
include "/home/buet/cadence/gpdk090_v4.6/models/spectre/gpdk090.scs" section=NN
include "../cells/cells.scs"
include "../cells/XOR2_TG/XOR2_TG.scs"
include "../blocks/XORTAP8.scs"
include "../blocks/CFSR_FB.scs"
include "tb_CFSR_FB_CMOS.scs"
