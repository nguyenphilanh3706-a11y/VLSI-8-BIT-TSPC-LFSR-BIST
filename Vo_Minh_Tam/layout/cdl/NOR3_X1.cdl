* TV3_CELLS/NOR3_X1: netlist from Virtuoso schematic
.SUBCKT NOR3_X1 A B C GND VDD Y
MMN2 Y C GND GND nmos1v w=120n l=100n
MMN1 Y B GND GND nmos1v w=120n l=100n
MMN0 Y A GND GND nmos1v w=120n l=100n
MMP2 Y C p2 VDD pmos1v w=480n l=100n
MMP1 p2 B p1 VDD pmos1v w=480n l=100n
MMP0 p1 A VDD VDD pmos1v w=480n l=100n
.ENDS NOR3_X1
