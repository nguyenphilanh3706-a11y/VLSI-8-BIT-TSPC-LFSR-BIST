* TV3_CELLS/CFSR_FB_OPT: netlist from Virtuoso schematic
.SUBCKT XOR2_TG6 A B GND VDD Y
MMN2 Y An B GND nmos1v w=120n l=100n
MMN1 Y B An GND nmos1v w=240n l=100n
MMN0 An A GND GND nmos1v w=120n l=100n
MMP2 Y A B VDD pmos1v w=240n l=100n
MMP1 Y B A VDD pmos1v w=480n l=100n
MMP0 An A VDD VDD pmos1v w=240n l=100n
.ENDS XOR2_TG6

.SUBCKT NOR3_X1 A B C GND VDD Y
MMN2 Y C GND GND nmos1v w=120n l=100n
MMN1 Y B GND GND nmos1v w=120n l=100n
MMN0 Y A GND GND nmos1v w=120n l=100n
MMP2 Y C p2 VDD pmos1v w=480n l=100n
MMP1 p2 B p1 VDD pmos1v w=480n l=100n
MMP0 p1 A VDD VDD pmos1v w=480n l=100n
.ENDS NOR3_X1

.SUBCKT AOI21_X1 A1 A2 B GND VDD Y
MMN2 Y B GND GND nmos1v w=120n l=100n
MMN1 n1 A2 GND GND nmos1v w=240n l=100n
MMN0 Y A1 n1 GND nmos1v w=240n l=100n
MMP2 Y B p1 VDD pmos1v w=480n l=100n
MMP1 p1 A2 VDD VDD pmos1v w=480n l=100n
MMP0 p1 A1 VDD VDD pmos1v w=480n l=100n
.ENDS AOI21_X1

.SUBCKT XNOR2_X1 A B GND VDD Y
MMN5 n2 B GND GND nmos1v w=240n l=100n
MMN4 Y An n2 GND nmos1v w=240n l=100n
MMN3 n1 Bn GND GND nmos1v w=240n l=100n
MMN2 Y A n1 GND nmos1v w=240n l=100n
MMN1 Bn B GND GND nmos1v w=120n l=100n
MMN0 An A GND GND nmos1v w=120n l=100n
MMP5 Y Bn p1 VDD pmos1v w=480n l=100n
MMP4 Y A p1 VDD pmos1v w=480n l=100n
MMP3 p1 B VDD VDD pmos1v w=480n l=100n
MMP2 p1 An VDD VDD pmos1v w=480n l=100n
MMP1 Bn B VDD VDD pmos1v w=240n l=100n
MMP0 An A VDD VDD pmos1v w=240n l=100n
.ENDS XNOR2_X1

.SUBCKT CFSR_FB_OPT FB GND Q0 Q1 Q2 Q3 Q4 Q5 Q6 Q7 VDD
XI1 Q6 Q7 GND VDD t67 XOR2_TG6
XI0 Q0 Q5 GND VDD t05 XOR2_TG6
XI3 Q3 Q4 Q6 GND VDD n346 NOR3_X1
XI2 Q0 Q1 Q2 GND VDD n012 NOR3_X1
XI4 n012 n346 t05 GND VDD wn AOI21_X1
XI5 t67 wn GND VDD FB XNOR2_X1
.ENDS CFSR_FB_OPT
