* TV3_CELLS/ZERO7: netlist from Virtuoso schematic
.SUBCKT NOR3_X1 A B C GND VDD Y
MMN2 Y C GND GND nmos1v w=120n l=100n
MMN1 Y B GND GND nmos1v w=120n l=100n
MMN0 Y A GND GND nmos1v w=120n l=100n
MMP2 Y C p2 VDD pmos1v w=480n l=100n
MMP1 p2 B p1 VDD pmos1v w=480n l=100n
MMP0 p1 A VDD VDD pmos1v w=480n l=100n
.ENDS NOR3_X1

.SUBCKT NAND2_X1 A B GND VDD Y
MMN1 n1 B GND GND nmos1v w=240n l=100n
MMN0 Y A n1 GND nmos1v w=240n l=100n
MMP1 Y B VDD VDD pmos1v w=240n l=100n
MMP0 Y A VDD VDD pmos1v w=240n l=100n
.ENDS NAND2_X1

.SUBCKT NOR2_X1 A B GND VDD Y
MMN1 Y B GND GND nmos1v w=120n l=100n
MMN0 Y A GND GND nmos1v w=120n l=100n
MMP1 Y B p1 VDD pmos1v w=480n l=100n
MMP0 p1 A VDD VDD pmos1v w=480n l=100n
.ENDS NOR2_X1

.SUBCKT ZERO7 GND Q0 Q1 Q2 Q3 Q4 Q5 Q6 VDD Z
XI1 Q3 Q4 Q5 GND VDD n345 NOR3_X1
XI0 Q0 Q1 Q2 GND VDD n012 NOR3_X1
XI2 n012 n345 GND VDD a NAND2_X1
XI3 a Q6 GND VDD Z NOR2_X1
.ENDS ZERO7
