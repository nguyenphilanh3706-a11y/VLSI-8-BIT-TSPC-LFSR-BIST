* TV3_CELLS/CFSR_FB_CMOS: netlist from Virtuoso schematic
.SUBCKT XOR2_X1 A B GND VDD Y
MMN5 n2 Bn GND GND nmos1v w=240n l=100n
MMN4 Y An n2 GND nmos1v w=240n l=100n
MMN3 n1 B GND GND nmos1v w=240n l=100n
MMN2 Y A n1 GND nmos1v w=240n l=100n
MMN1 Bn B GND GND nmos1v w=120n l=100n
MMN0 An A GND GND nmos1v w=120n l=100n
MMP5 Y Bn p1 VDD pmos1v w=480n l=100n
MMP4 Y An p1 VDD pmos1v w=480n l=100n
MMP3 p1 B VDD VDD pmos1v w=480n l=100n
MMP2 p1 A VDD VDD pmos1v w=480n l=100n
MMP1 Bn B VDD VDD pmos1v w=240n l=100n
MMP0 An A VDD VDD pmos1v w=240n l=100n
.ENDS XOR2_X1

.SUBCKT XORTAP8_CMOS FB GND Q0 Q5 Q6 Q7 VDD
XI2 t05 t67 GND VDD FB XOR2_X1
XI1 Q6 Q7 GND VDD t67 XOR2_X1
XI0 Q0 Q5 GND VDD t05 XOR2_X1
.ENDS XORTAP8_CMOS

.SUBCKT NOR2_X1 A B GND VDD Y
MMN1 Y B GND GND nmos1v w=120n l=100n
MMN0 Y A GND GND nmos1v w=120n l=100n
MMP1 Y B p1 VDD pmos1v w=480n l=100n
MMP0 p1 A VDD VDD pmos1v w=480n l=100n
.ENDS NOR2_X1

.SUBCKT INV_X1 A GND VDD Y
MMN0 Y A GND GND nmos1v w=120n l=100n
MMP0 Y A VDD VDD pmos1v w=240n l=100n
.ENDS INV_X1

.SUBCKT NAND2_X1 A B GND VDD Y
MMN1 n1 B GND GND nmos1v w=240n l=100n
MMN0 Y A n1 GND nmos1v w=240n l=100n
MMP1 Y B VDD VDD pmos1v w=240n l=100n
MMP0 Y A VDD VDD pmos1v w=240n l=100n
.ENDS NAND2_X1

.SUBCKT CFSR_FB_CMOS FB GND Q0 Q1 Q2 Q3 Q4 Q5 Q6 Q7 VDD
XI0 tap GND Q0 Q5 Q6 Q7 VDD XORTAP8_CMOS
XI7 a b GND VDD z NOR2_X1
XI3 Q4 Q5 GND VDD n45 NOR2_X1
XI2 Q2 Q3 GND VDD n23 NOR2_X1
XI1 Q0 Q1 GND VDD n01 NOR2_X1
XI4 Q6 GND VDD q6n INV_X1
XI6 n45 q6n GND VDD b NAND2_X1
XI5 n01 n23 GND VDD a NAND2_X1
XI8 tap z GND VDD FB XOR2_X1
.ENDS CFSR_FB_CMOS
