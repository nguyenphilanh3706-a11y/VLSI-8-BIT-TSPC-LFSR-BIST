* TV3_CELLS/XORTAP8: netlist from Virtuoso schematic
.SUBCKT XOR2_TG6 A B GND VDD Y
MMN2 Y An B GND nmos1v w=120n l=100n
MMN1 Y B An GND nmos1v w=240n l=100n
MMN0 An A GND GND nmos1v w=120n l=100n
MMP2 Y A B VDD pmos1v w=240n l=100n
MMP1 Y B A VDD pmos1v w=480n l=100n
MMP0 An A VDD VDD pmos1v w=240n l=100n
.ENDS XOR2_TG6

.SUBCKT XOR2_X1 A B GND VDD Y
MMN5 n2 Bn GND GND nmos1v w=240n l=100n
MMN4 Y An n2 GND nmos1v w=240n l=100n
MMN3 n1 B GND GND nmos1v w=240n l=100n
MMN2 Y A n1 GND nmos1v w=240n l=100n
MMN1 Bn B GND GND nmos1v w=120n l=100n
MMN0 An A GND GND nmos1v w=120n l=100n
MMP5 Y Bn p1 VDD pmos1v w=480n l=100n
MMP4 Y An p1 VDD pmos1v w=480n l=100n
MMP3 p1 B VDD VDD pmos1v w=480n l=100n
MMP2 p1 A VDD VDD pmos1v w=480n l=100n
MMP1 Bn B VDD VDD pmos1v w=240n l=100n
MMP0 An A VDD VDD pmos1v w=240n l=100n
.ENDS XOR2_X1

.SUBCKT XORTAP8 FB GND Q0 Q5 Q6 Q7 VDD
XI1 Q6 Q7 GND VDD t67 XOR2_TG6
XI0 Q0 Q5 GND VDD t05 XOR2_TG6
XI2 t05 t67 GND VDD FB XOR2_X1
.ENDS XORTAP8
