* TV3_CELLS/CFSR_FB: netlist from Virtuoso schematic
.SUBCKT XOR2_TG6 A B GND VDD Y
MMN2 Y An B GND nmos1v w=120n l=100n
MMN1 Y B An GND nmos1v w=240n l=100n
MMN0 An A GND GND nmos1v w=120n l=100n
MMP2 Y A B VDD pmos1v w=240n l=100n
MMP1 Y B A VDD pmos1v w=480n l=100n
MMP0 An A VDD VDD pmos1v w=240n l=100n
.ENDS XOR2_TG6

.SUBCKT XOR2_X1 A B GND VDD Y
MMN5 n2 Bn GND GND nmos1v w=240n l=100n
MMN4 Y An n2 GND nmos1v w=240n l=100n
MMN3 n1 B GND GND nmos1v w=240n l=100n
MMN2 Y A n1 GND nmos1v w=240n l=100n
MMN1 Bn B GND GND nmos1v w=120n l=100n
MMN0 An A GND GND nmos1v w=120n l=100n
MMP5 Y Bn p1 VDD pmos1v w=480n l=100n
MMP4 Y An p1 VDD pmos1v w=480n l=100n
MMP3 p1 B VDD VDD pmos1v w=480n l=100n
MMP2 p1 A VDD VDD pmos1v w=480n l=100n
MMP1 Bn B VDD VDD pmos1v w=240n l=100n
MMP0 An A VDD VDD pmos1v w=240n l=100n
.ENDS XOR2_X1

.SUBCKT XORTAP8 FB GND Q0 Q5 Q6 Q7 VDD
XI1 Q6 Q7 GND VDD t67 XOR2_TG6
XI0 Q0 Q5 GND VDD t05 XOR2_TG6
XI2 t05 t67 GND VDD FB XOR2_X1
.ENDS XORTAP8

.SUBCKT NOR3_X1 A B C GND VDD Y
MMN2 Y C GND GND nmos1v w=120n l=100n
MMN1 Y B GND GND nmos1v w=120n l=100n
MMN0 Y A GND GND nmos1v w=120n l=100n
MMP2 Y C p2 VDD pmos1v w=480n l=100n
MMP1 p2 B p1 VDD pmos1v w=480n l=100n
MMP0 p1 A VDD VDD pmos1v w=480n l=100n
.ENDS NOR3_X1

.SUBCKT NAND2_X1 A B GND VDD Y
MMN1 n1 B GND GND nmos1v w=240n l=100n
MMN0 Y A n1 GND nmos1v w=240n l=100n
MMP1 Y B VDD VDD pmos1v w=240n l=100n
MMP0 Y A VDD VDD pmos1v w=240n l=100n
.ENDS NAND2_X1

.SUBCKT NOR2_X1 A B GND VDD Y
MMN1 Y B GND GND nmos1v w=120n l=100n
MMN0 Y A GND GND nmos1v w=120n l=100n
MMP1 Y B p1 VDD pmos1v w=480n l=100n
MMP0 p1 A VDD VDD pmos1v w=480n l=100n
.ENDS NOR2_X1

.SUBCKT ZERO7 GND Q0 Q1 Q2 Q3 Q4 Q5 Q6 VDD Z
XI1 Q3 Q4 Q5 GND VDD n345 NOR3_X1
XI0 Q0 Q1 Q2 GND VDD n012 NOR3_X1
XI2 n012 n345 GND VDD a NAND2_X1
XI3 a Q6 GND VDD Z NOR2_X1
.ENDS ZERO7

.SUBCKT CFSR_FB FB GND Q0 Q1 Q2 Q3 Q4 Q5 Q6 Q7 VDD
XI0 tap GND Q0 Q5 Q6 Q7 VDD XORTAP8
XI1 GND Q0 Q1 Q2 Q3 Q4 Q5 Q6 VDD z ZERO7
XI2 tap z GND VDD FB XOR2_X1
.ENDS CFSR_FB
