// XNOR2_X1 sau layout (Assura RCX), cmp, corner NN
simulator lang=spectre
include "/home/buet/cadence/gpdk090_v4.6/models/spectre/gpdk090.scs" section=NN
include "../../cells/INV_X1/INV_X1.scs"
include "XNOR2_X1_rcx.scs"
include "../../tb/tb_XNOR2_X1_cmp.scs"
