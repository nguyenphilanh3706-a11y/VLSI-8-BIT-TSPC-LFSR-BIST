// XOR2_X1 layout nen 15 cot (ban toi uu) sau layout: Assura RCX
simulator lang=spectre
subckt XOR2_X1 A B Y VDD GND
    I_MN0 (An_3 A_5 GND GND) gpdk090_nmos1v w=0.12u l=0.1u ad=0.0696p as=0.0468p pd=1.16u ps=0.68u
    I_MN3 (n1 B_3 GND GND) gpdk090_nmos1v w=0.24u l=0.1u ad=0.0528p as=0.0468p pd=0.68u ps=0.68u
    I_MN2 (Y_1 A_9 n1 GND) gpdk090_nmos1v w=0.24u l=0.1u ad=0.0528p as=0.0528p pd=0.68u ps=0.68u
    I_MN4 (Y_1 An_7 n2 GND) gpdk090_nmos1v w=0.24u l=0.1u ad=0.0528p as=0.0528p pd=0.68u ps=0.68u
    I_MN5 (n2 Bn_4 GND GND) gpdk090_nmos1v w=0.24u l=0.1u ad=0.0528p as=0.1116p pd=0.68u ps=1.22u
    I_MN1 (Bn_7 B_11 GND GND) gpdk090_nmos1v w=0.12u l=0.1u ad=0.0696p as=0.1116p pd=1.16u ps=1.22u
    I_MP0 (An A_3 VDD VDD) gpdk090_pmos1v w=0.24u l=0.1u ad=0.0816p as=0.1584p pd=1.16u ps=1.46u
    I_MP2 (p1_2 A_8 VDD VDD) gpdk090_pmos1v w=0.48u l=0.1u ad=0.1056p as=0.1584p pd=0.92u ps=1.46u
    I_MP4 (Y_3 An_6 p1_2 VDD) gpdk090_pmos1v w=0.48u l=0.1u ad=0.1056p as=0.1056p pd=0.92u ps=0.92u
    I_MP5 (Y_3 Bn_3 p1_4 VDD) gpdk090_pmos1v w=0.48u l=0.1u ad=0.1056p as=0.1056p pd=0.92u ps=0.92u
    I_MP3 (p1_4 B_6 VDD VDD) gpdk090_pmos1v w=0.48u l=0.1u ad=0.1056p as=0.0936p pd=0.92u ps=0.92u
    I_MP1 (Bn_5 B_10 VDD VDD) gpdk090_pmos1v w=0.24u l=0.1u ad=0.0816p as=0.0936p pd=1.16u ps=0.92u
    I_Rj1 (A_3 A_4) resistor r=48.5435
    I_Rj2 (A_4 A_5) resistor r=54.5435
    I_Rj3 (A_1 A_4) resistor r=10.0000
    I_Rj4 (B_3 B_1) resistor r=48.5435
    I_Rj5 (A_8 A_6) resistor r=36.5435
    I_Rj6 (A_6 A_9) resistor r=48.5435
    I_Rj7 (An_6 An_4) resistor r=36.5435
    I_Rj8 (An_4 An_7) resistor r=48.5435
    I_Rj9 (Bn_3 Bn) resistor r=36.5435
    I_Rj10 (Bn Bn_4) resistor r=48.5435
    I_Rj11 (B_6 B_4) resistor r=36.5435
    I_Rj12 (B_10 B_7) resistor r=48.5435
    I_Rj13 (B_7 B_11) resistor r=54.5435
    I_Ri1 (An An_2) resistor r=15.4907
    I_Ri2 (An_2 An_3) resistor r=15.2347
    I_Ri3 (A_1 A) resistor r=6.133E-02
    I_Ri4 (A A_2) resistor r=1.5200
    I_Ri5 (B_1 B_2) resistor r=11.4267
    I_Ri6 (A_6 A_7) resistor r=11.5813
    I_Ri7 (p1 p1_2) resistor r=16.4267
    I_Ri8 (Y_1 Y) resistor r=15.0453
    I_Ri9 (Y Y_2) resistor r=1.4347
    I_Ri10 (An_4 An_5) resistor r=11.5280
    I_Ri11 (Y_3 Y_4) resistor r=17.0453
    I_Ri12 (Bn Bn_2) resistor r=11.5280
    I_Ri13 (p1_3 p1_4) resistor r=16.4267
    I_Ri14 (B_4 B_5) resistor r=10.0267
    I_Ri15 (B_5 B) resistor r=3.467E-02
    I_Ri16 (B_7 B_8) resistor r=11.4267
    I_Ri17 (Bn_5 Bn_6) resistor r=15.4907
    I_Ri18 (Bn_6 Bn_7) resistor r=15.2347
    I_Rh1 (A_7 A_2) resistor r=0.4320
    I_Rh2 (An_5 An_2) resistor r=2.1560
    I_Rh3 (Y_4 Y_2) resistor r=0.2160
    I_Rh4 (p1_3 p1) resistor r=0.4320
    I_Rh5 (B_8 B_9) resistor r=0.2160
    I_Rh6 (B_9 B_2) resistor r=0.8640
    I_Rh7 (B_5 B_9) resistor r=1.4000
    I_Rh8 (Bn_6 Bn_2) resistor r=1.9400
    I_C1 (VDD GND) capacitor c=5.608E-16
    I_C2 (Y GND) capacitor c=7.881E-17
    I_C3 (p1 GND) capacitor c=1.455E-16
    I_C4 (n2 GND) capacitor c=1.184E-17
    I_C5 (Bn GND) capacitor c=1.086E-16
    I_C6 (An GND) capacitor c=7.424E-17
    I_C7 (A_3 GND) capacitor c=4.909E-17
    I_C8 (A_8 GND) capacitor c=6.007E-17
    I_C9 (An_6 GND) capacitor c=6.567E-17
    I_C10 (Bn_3 GND) capacitor c=6.463E-17
    I_C11 (B_6 GND) capacitor c=5.724E-17
    I_C12 (B_10 GND) capacitor c=4.832E-17
    I_C13 (A_5 GND) capacitor c=5.540E-17
    I_C14 (B_3 GND) capacitor c=5.833E-17
    I_C15 (A_9 GND) capacitor c=5.776E-17
    I_C16 (An_7 GND) capacitor c=5.368E-17
    I_C17 (Bn_4 GND) capacitor c=5.435E-17
    I_C18 (B_11 GND) capacitor c=5.667E-17
    I_C19 (A_1 GND) capacitor c=1.344E-16
    I_C20 (B_1 GND) capacitor c=1.247E-16
    I_C21 (A_6 GND) capacitor c=9.631E-17
    I_C22 (An_4 GND) capacitor c=1.070E-16
    I_C23 (B_4 GND) capacitor c=7.737E-17
    I_C24 (B_7 GND) capacitor c=1.275E-16
    I_C25 (An_2 GND) capacitor c=2.037E-16
    I_C26 (A_2 GND) capacitor c=1.112E-16
    I_C27 (B_2 GND) capacitor c=2.657E-16
    I_C28 (A_7 GND) capacitor c=1.470E-16
    I_C29 (Y_2 GND) capacitor c=6.103E-17
    I_C30 (An_5 GND) capacitor c=2.693E-16
    I_C31 (Y_4 GND) capacitor c=1.980E-16
    I_C32 (Bn_2 GND) capacitor c=1.720E-16
    I_C33 (p1_3 GND) capacitor c=1.306E-16
    I_C34 (B_5 GND) capacitor c=2.085E-16
    I_C35 (B_8 GND) capacitor c=6.162E-17
    I_C36 (Bn_6 GND) capacitor c=1.965E-16
    I_C37 (p1_2 GND) capacitor c=2.715E-18
    I_C38 (Y_3 GND) capacitor c=1.221E-16
    I_C39 (Bn_5 GND) capacitor c=6.949E-17
    I_C40 (An_3 GND) capacitor c=3.633E-17
    I_C41 (Bn_7 GND) capacitor c=3.499E-17
ends XOR2_X1
