// XOR2_X1 layout nen 15 cot (ban toi uu) sau layout (Assura RCX), cmp, corner FF
simulator lang=spectre
include "/home/buet/cadence/gpdk090_v4.6/models/spectre/gpdk090.scs" section=FF
include "../../cells/INV_X1/INV_X1.scs"
include "XOR2_X1_OPT_rcx.scs"
include "../../tb/tb_XOR2_X1_cmp.scs"
