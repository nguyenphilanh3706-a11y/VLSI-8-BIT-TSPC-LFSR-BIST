// NOR2_X1 sau layout: Assura RCX
simulator lang=spectre
subckt NOR2_X1 A B Y VDD GND
    I_MN1 (Y_2 B_4 GND GND) gpdk090_nmos1v w=0.12u l=0.1u ad=0.0696p as=0.0408p pd=1.16u ps=0.68u
    I_MN0 (Y_4 A_4 GND GND) gpdk090_nmos1v w=0.12u l=0.1u ad=0.0696p as=0.0408p pd=1.16u ps=0.68u
    I_MP1 (Y_3 B_2 p1 VDD) gpdk090_pmos1v w=0.48u l=0.1u ad=0.1632p as=0.1056p pd=1.64u ps=0.92u
    I_MP0 (p1 A_2 VDD VDD) gpdk090_pmos1v w=0.48u l=0.1u ad=0.1056p as=0.1632p pd=0.92u ps=1.64u
    I_Rj1 (B_2 B_3) resistor r=36.5435
    I_Rj2 (B_3 B_4) resistor r=54.5435
    I_Rj3 (B B_3) resistor r=10.0000
    I_Rj4 (A_2 A_3) resistor r=36.5435
    I_Rj5 (A_3 A_4) resistor r=54.5435
    I_Rj6 (A A_3) resistor r=10.0000
    I_Ri1 (Y Y_1) resistor r=6.667E-02
    I_Ri2 (Y_1 Y_2) resistor r=15.0800
    I_Ri3 (Y Y_3) resistor r=15.5787
    I_Ri6 (Y_4 Y_5) resistor r=16.4800
    I_Rh1 (Y_5 Y_1) resistor r=1.8320
    I_C1 (VDD GND) capacitor c=1.563E-16
    I_C2 (A GND) capacitor c=1.187E-16
    I_C3 (B GND) capacitor c=1.610E-16
    I_C4 (B_2 GND) capacitor c=5.525E-17
    I_C5 (A_2 GND) capacitor c=5.348E-17
    I_C6 (B_4 GND) capacitor c=5.741E-17
    I_C7 (A_4 GND) capacitor c=5.756E-17
    I_C8 (Y_1 GND) capacitor c=1.529E-16
    I_C9 (Y_5 GND) capacitor c=8.320E-17
    I_C10 (Y_3 GND) capacitor c=6.042E-17
    I_C11 (Y_2 GND) capacitor c=2.251E-17
    I_C12 (Y_4 GND) capacitor c=3.526E-17
ends NOR2_X1
