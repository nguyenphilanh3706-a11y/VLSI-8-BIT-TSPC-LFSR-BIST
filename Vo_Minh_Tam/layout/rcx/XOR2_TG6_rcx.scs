// XOR2_TG6 sau layout: Assura RCX
simulator lang=spectre
subckt XOR2_TG6 A B Y VDD GND
    I_MN2 (Y_1 An_5 B_1 GND) gpdk090_nmos1v w=0.12u l=0.1u ad=0.0468p as=0.1992p pd=0.68u ps=2.24u
    I_MN1 (Y_1 B_6 An_6 GND) gpdk090_nmos1v w=0.24u l=0.1u ad=0.0468p as=0.0468p pd=0.68u ps=0.68u
    I_MN0 (An_6 A_9 GND GND) gpdk090_nmos1v w=0.12u l=0.1u ad=0.0468p as=0.0696p pd=0.68u ps=1.16u
    I_MP0 (An A_3 VDD VDD) gpdk090_pmos1v w=0.24u l=0.1u ad=0.0816p as=0.0816p pd=1.16u ps=1.16u
    I_MP1 (Y_4 B_5 A_5 VDD) gpdk090_pmos1v w=0.48u l=0.1u ad=0.0936p as=0.1632p pd=0.92u ps=1.64u
    I_MP2 (Y_4 A_8 B_8 VDD) gpdk090_pmos1v w=0.24u l=0.1u ad=0.0936p as=0.0816p pd=0.92u ps=1.16u
    I_Rj1 (A_3 A_1) resistor r=58.5435
    I_Rj2 (An_5 An_3) resistor r=54.5435
    I_Rj3 (B_5 B_3) resistor r=36.5435
    I_Rj4 (B_3 B_6) resistor r=48.5435
    I_Rj5 (A_8 A_6) resistor r=48.5435
    I_Rj6 (A_6 A_9) resistor r=54.5435
    I_Ri1 (An An_2) resistor r=17.0453
    I_Ri2 (A_1 A) resistor r=6.133E-02
    I_Ri3 (A A_2) resistor r=1.6747
    I_Ri4 (B_1 B_2) resistor r=16.6347
    I_Ri5 (An_3 An_4) resistor r=11.6827
    I_Ri6 (A_4 A_5) resistor r=16.4267
    I_Ri7 (Y_1 Y_2) resistor r=16.7893
    I_Ri8 (B_3 B_4) resistor r=11.5280
    I_Ri9 (Y_3 Y) resistor r=3.467E-02
    I_Ri10 (Y Y_4) resistor r=15.3013
    I_Ri11 (An_6 An_7) resistor r=16.4800
    I_Ri12 (A_6 A_7) resistor r=11.7360
    I_Ri13 (B B_7) resistor r=1.5307
    I_Ri14 (B B_8) resistor r=15.3600
    I_Rh1 (Y_3 Y_2) resistor r=1.6160
    I_Rh2 (An_7 An_4) resistor r=0.3240
    I_Rh3 (An_4 An_2) resistor r=0.3240
    I_Rh4 (A_7 A_4) resistor r=0.3240
    I_Rh5 (A_4 A_2) resistor r=0.3240
    I_Rh6 (B_7 B_4) resistor r=0.3240
    I_Rh7 (B_4 B_2) resistor r=0.3240
    I_C1 (VDD GND) capacitor c=3.794E-16
    I_C2 (A GND) capacitor c=9.464E-17
    I_C3 (B GND) capacitor c=8.653E-17
    I_C4 (Y GND) capacitor c=1.153E-16
    I_C5 (An GND) capacitor c=1.253E-16
    I_C6 (A_3 GND) capacitor c=5.329E-17
    I_C7 (B_5 GND) capacitor c=6.564E-17
    I_C8 (A_8 GND) capacitor c=4.512E-17
    I_C9 (An_5 GND) capacitor c=4.637E-17
    I_C10 (B_6 GND) capacitor c=6.064E-17
    I_C11 (A_9 GND) capacitor c=5.750E-17
    I_C12 (A_1 GND) capacitor c=5.327E-17
    I_C13 (An_3 GND) capacitor c=1.426E-16
    I_C14 (B_3 GND) capacitor c=1.265E-16
    I_C15 (A_6 GND) capacitor c=1.739E-16
    I_C16 (An_2 GND) capacitor c=1.523E-16
    I_C17 (A_2 GND) capacitor c=1.171E-16
    I_C18 (B_2 GND) capacitor c=1.752E-16
    I_C19 (An_4 GND) capacitor c=2.008E-16
    I_C20 (Y_2 GND) capacitor c=2.048E-16
    I_C21 (A_4 GND) capacitor c=1.203E-16
    I_C22 (B_4 GND) capacitor c=2.342E-16
    I_C23 (An_7 GND) capacitor c=1.313E-16
    I_C24 (Y_3 GND) capacitor c=7.937E-17
    I_C25 (A_7 GND) capacitor c=1.478E-16
    I_C26 (B_7 GND) capacitor c=7.582E-17
    I_C27 (Y_4 GND) capacitor c=8.060E-17
    I_C28 (B_8 GND) capacitor c=7.462E-17
    I_C29 (B_1 GND) capacitor c=7.926E-17
    I_C30 (Y_1 GND) capacitor c=1.014E-16
    I_C31 (An_6 GND) capacitor c=4.140E-17
ends XOR2_TG6
