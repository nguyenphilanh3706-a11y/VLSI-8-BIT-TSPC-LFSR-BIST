// CFSR_FB_CMOS sau layout: Assura RCX
simulator lang=spectre
subckt CFSR_FB_CMOS Q0 Q1 Q2 Q3 Q4 Q5 Q6 Q7 FB VDD GND
    I_MXI7_MN1 (GND b_14 z_9 GND) gpdk090_nmos1v w=0.12u l=0.1u ad=0.0408p as=0.0696p pd=0.68u ps=1.16u
    I_MXI7_MN0 (z_12 a_14 GND GND) gpdk090_nmos1v w=0.12u l=0.1u ad=0.0696p as=0.0408p pd=1.16u ps=0.68u
    I_MXI1_MN1 (GND Q1_4 n01_11 GND) gpdk090_nmos1v w=0.12u l=0.1u ad=0.0408p as=0.0696p pd=0.68u ps=1.16u
    I_MXI1_MN0 (n01_16 Q0_19 GND GND) gpdk090_nmos1v w=0.12u l=0.1u ad=0.0696p as=0.0408p pd=1.16u ps=0.68u
    I_MXI2_MN1 (GND Q3_4 n23_3 GND) gpdk090_nmos1v w=0.12u l=0.1u ad=0.0408p as=0.0696p pd=0.68u ps=1.16u
    I_MXI2_MN0 (n23_17 Q2_4 GND GND) gpdk090_nmos1v w=0.12u l=0.1u ad=0.0696p as=0.0408p pd=1.16u ps=0.68u
    I_MXI3_MN1 (GND Q5_12 n45 GND) gpdk090_nmos1v w=0.12u l=0.1u ad=0.0408p as=0.0696p pd=0.68u ps=1.16u
    I_MXI3_MN0 (n45_13 Q4_4 GND GND) gpdk090_nmos1v w=0.12u l=0.1u ad=0.0696p as=0.0408p pd=1.16u ps=0.68u
    I_MXI8_MN1 (XI8_Bn_3 z_4 GND GND) gpdk090_nmos1v w=0.12u l=0.1u ad=0.0696p as=0.0696p pd=1.16u ps=1.16u
    I_MXI8_MN5 (XI8_n2 XI8_Bn_7 GND GND) gpdk090_nmos1v w=0.24u l=0.1u ad=0.0528p as=0.0816p pd=0.68u ps=1.16u
    I_MXI8_MN4 (FB_6 XI8_An_3 XI8_n2 GND) gpdk090_nmos1v w=0.24u l=0.1u ad=0.0528p as=0.0528p pd=0.68u ps=0.68u
    I_MXI8_MN2 (XI8_n1 tap_3 FB_6 GND) gpdk090_nmos1v w=0.24u l=0.1u ad=0.0528p as=0.0528p pd=0.68u ps=0.68u
    I_MXI8_MN3 (GND z_17 XI8_n1 GND) gpdk090_nmos1v w=0.24u l=0.1u ad=0.0816p as=0.0528p pd=1.16u ps=0.68u
    I_MXI8_MN0 (XI8_An_7 tap_18 GND GND) gpdk090_nmos1v w=0.12u l=0.1u ad=0.0696p as=0.0696p pd=1.16u ps=1.16u
    I_MXI0_I1_MN1 (XI0_I1_Bn_3 Q7_4 GND GND) gpdk090_nmos1v w=0.12u l=0.1u ad=0.0696p as=0.0696p pd=1.16u ps=1.16u
    I_MXI0_I1_MN5 (XI0_I1_n2 XI0_I1_Bn_7 GND GND) gpdk090_nmos1v w=0.24u l=0.1u ad=0.0528p as=0.0816p pd=0.68u ps=1.16u
    I_MXI0_I1_MN4 (I0_t67_5 XI0_I1_An_3 XI0_I1_n2 GND) gpdk090_nmos1v w=0.24u l=0.1u ad=0.0528p as=0.0528p pd=0.68u ps=0.68u
    I_MXI0_I1_MN2 (XI0_I1_n1 Q6_11 I0_t67_5 GND) gpdk090_nmos1v w=0.24u l=0.1u ad=0.0528p as=0.0528p pd=0.68u ps=0.68u
    I_MXI0_I1_MN3 (GND Q7_10 XI0_I1_n1 GND) gpdk090_nmos1v w=0.24u l=0.1u ad=0.0816p as=0.0528p pd=1.16u ps=0.68u
    I_MXI0_I1_MN0 (XI0_I1_An_7 Q6_20 GND GND) gpdk090_nmos1v w=0.12u l=0.1u ad=0.0696p as=0.0696p pd=1.16u ps=1.16u
    I_MXI0_I2_MN1 (XI0_I2_Bn_3 I0_t67_13 GND GND) gpdk090_nmos1v w=0.12u l=0.1u ad=0.0696p as=0.0696p pd=1.16u ps=1.16u
    I_MXI0_I2_MN5 (XI0_I2_n2 XI0_I2_Bn_8 GND GND) gpdk090_nmos1v w=0.24u l=0.1u ad=0.0528p as=0.0816p pd=0.68u ps=1.16u
    I_MXI0_I2_MN4 (tap_7 XI0_I2_An_4 XI0_I2_n2 GND) gpdk090_nmos1v w=0.24u l=0.1u ad=0.0528p as=0.0528p pd=0.68u ps=0.68u
    I_MXI0_I2_MN2 (XI0_I2_n1 I0_t05_12 tap_7 GND) gpdk090_nmos1v w=0.24u l=0.1u ad=0.0528p as=0.0528p pd=0.68u ps=0.68u
    I_MXI0_I2_MN3 (GND I0_t67_20 XI0_I2_n1 GND) gpdk090_nmos1v w=0.24u l=0.1u ad=0.0816p as=0.0528p pd=1.16u ps=0.68u
    I_MXI0_I2_MN0 (XI0_I2_An_7 I0_t05_19 GND GND) gpdk090_nmos1v w=0.12u l=0.1u ad=0.0696p as=0.0696p pd=1.16u ps=1.16u
    I_MXI0_I0_MN1 (XI0_I0_Bn_3 Q5_5 GND GND) gpdk090_nmos1v w=0.12u l=0.1u ad=0.0696p as=0.0696p pd=1.16u ps=1.16u
    I_MXI0_I0_MN5 (XI0_I0_n2 XI0_I0_Bn_8 GND GND) gpdk090_nmos1v w=0.24u l=0.1u ad=0.0528p as=0.0816p pd=0.68u ps=1.16u
    I_MXI0_I0_MN4 (I0_t05_5 XI0_I0_An_4 XI0_I0_n2 GND) gpdk090_nmos1v w=0.24u l=0.1u ad=0.0528p as=0.0528p pd=0.68u ps=0.68u
    I_MXI0_I0_MN2 (XI0_I0_n1 Q0_4 I0_t05_5 GND) gpdk090_nmos1v w=0.24u l=0.1u ad=0.0528p as=0.0528p pd=0.68u ps=0.68u
    I_MXI0_I0_MN3 (GND Q5_18 XI0_I0_n1 GND) gpdk090_nmos1v w=0.24u l=0.1u ad=0.0816p as=0.0528p pd=1.16u ps=0.68u
    I_MXI0_I0_MN0 (XI0_I0_An_7 Q0_12 GND GND) gpdk090_nmos1v w=0.12u l=0.1u ad=0.0696p as=0.0696p pd=1.16u ps=1.16u
    I_MXI4_MN0 (q6n_3 Q6_7 GND GND) gpdk090_nmos1v w=0.12u l=0.1u ad=0.0696p as=0.0696p pd=1.16u ps=1.16u
    I_MXI5_MN0 (XI5_n1 n01_6 a_6 GND) gpdk090_nmos1v w=0.24u l=0.1u ad=0.0528p as=0.0816p pd=0.68u ps=1.16u
    I_MXI5_MN1 (GND n23_16 XI5_n1 GND) gpdk090_nmos1v w=0.24u l=0.1u ad=0.0816p as=0.0528p pd=1.16u ps=0.68u
    I_MXI6_MN0 (XI6_n1 n45_16 b_8 GND) gpdk090_nmos1v w=0.24u l=0.1u ad=0.0528p as=0.0816p pd=0.68u ps=1.16u
    I_MXI6_MN1 (GND q6n_13 XI6_n1 GND) gpdk090_nmos1v w=0.24u l=0.1u ad=0.0816p as=0.0528p pd=1.16u ps=0.68u
    I_MXI7_MP1 (XI7_p1 b_13 z_6 VDD) gpdk090_pmos1v w=0.48u l=0.1u ad=0.1056p as=0.1632p pd=0.92u ps=1.64u
    I_MXI7_MP0 (VDD a_12 XI7_p1 VDD) gpdk090_pmos1v w=0.48u l=0.1u ad=0.1632p as=0.1056p pd=1.64u ps=0.92u
    I_MXI1_MP1 (XI1_p1 Q1_6 n01_15 VDD) gpdk090_pmos1v w=0.48u l=0.1u ad=0.1056p as=0.1632p pd=0.92u ps=1.64u
    I_MXI1_MP0 (VDD Q0_21 XI1_p1 VDD) gpdk090_pmos1v w=0.48u l=0.1u ad=0.1632p as=0.1056p pd=1.64u ps=0.92u
    I_MXI2_MP1 (XI2_p1 Q3_6 n23_6 VDD) gpdk090_pmos1v w=0.48u l=0.1u ad=0.1056p as=0.1632p pd=0.92u ps=1.64u
    I_MXI2_MP0 (VDD Q2_6 XI2_p1 VDD) gpdk090_pmos1v w=0.48u l=0.1u ad=0.1632p as=0.1056p pd=1.64u ps=0.92u
    I_MXI3_MP1 (XI3_p1 Q5_14 n45_4 VDD) gpdk090_pmos1v w=0.48u l=0.1u ad=0.1056p as=0.1632p pd=0.92u ps=1.64u
    I_MXI3_MP0 (VDD Q4_6 XI3_p1 VDD) gpdk090_pmos1v w=0.48u l=0.1u ad=0.1632p as=0.1056p pd=1.64u ps=0.92u
    I_MXI8_MP1 (VDD z_5 XI8_Bn VDD) gpdk090_pmos1v w=0.24u l=0.1u ad=0.0816p as=0.0816p pd=1.16u ps=1.16u
    I_MXI8_MP5 (FB_2 XI8_Bn_8 XI8_p1 VDD) gpdk090_pmos1v w=0.48u l=0.1u ad=0.1056p as=0.1632p pd=0.92u ps=1.64u
    I_MXI8_MP4 (XI8_p1_3 XI8_An_4 FB_2 VDD) gpdk090_pmos1v w=0.48u l=0.1u ad=0.1056p as=0.1056p pd=0.92u ps=0.92u
    I_MXI8_MP2 (VDD tap_4 XI8_p1_3 VDD) gpdk090_pmos1v w=0.48u l=0.1u ad=0.1056p as=0.1056p pd=0.92u ps=0.92u
    I_MXI8_MP3 (XI8_p1_5 z_18 VDD VDD) gpdk090_pmos1v w=0.48u l=0.1u ad=0.1632p as=0.1056p pd=1.64u ps=0.92u
    I_MXI8_MP0 (VDD tap_20 XI8_An_5 VDD) gpdk090_pmos1v w=0.24u l=0.1u ad=0.0816p as=0.0816p pd=1.16u ps=1.16u
    I_MXI0_I1_MP1 (VDD Q7_5 XI0_I1_Bn VDD) gpdk090_pmos1v w=0.24u l=0.1u ad=0.0816p as=0.0816p pd=1.16u ps=1.16u
    I_MXI0_I1_MP5 (I0_t67 XI0_I1_Bn_8 XI0_I1_p1 VDD) gpdk090_pmos1v w=0.48u l=0.1u ad=0.1056p as=0.1632p pd=0.92u ps=1.64u
    I_MXI0_I1_MP4 (XI0_I1_p1_3 XI0_I1_An_4 I0_t67 VDD) gpdk090_pmos1v w=0.48u l=0.1u ad=0.1056p as=0.1056p pd=0.92u ps=0.92u
    I_MXI0_I1_MP2 (VDD Q6_12 XI0_I1_p1_3 VDD) gpdk090_pmos1v w=0.48u l=0.1u ad=0.1056p as=0.1056p pd=0.92u ps=0.92u
    I_MXI0_I1_MP3 (XI0_I1_p1_6 Q7_11 VDD VDD) gpdk090_pmos1v w=0.48u l=0.1u ad=0.1632p as=0.1056p pd=1.64u ps=0.92u
    I_MXI0_I1_MP0 (VDD Q6_22 XI0_I1_An_5 VDD) gpdk090_pmos1v w=0.24u l=0.1u ad=0.0816p as=0.0816p pd=1.16u ps=1.16u
    I_MXI0_I2_MP1 (VDD I0_t67_12 XI0_I2_Bn VDD) gpdk090_pmos1v w=0.24u l=0.1u ad=0.0816p as=0.0816p pd=1.16u ps=1.16u
    I_MXI0_I2_MP5 (tap_5 XI0_I2_Bn_7 XI0_I2_p1_2 VDD) gpdk090_pmos1v w=0.48u l=0.1u ad=0.1056p as=0.1632p pd=0.92u ps=1.64u
    I_MXI0_I2_MP4 (XI0_I2_p1_4 XI0_I2_An_3 tap_5 VDD) gpdk090_pmos1v w=0.48u l=0.1u ad=0.1056p as=0.1056p pd=0.92u ps=0.92u
    I_MXI0_I2_MP2 (VDD I0_t05_11 XI0_I2_p1_4 VDD) gpdk090_pmos1v w=0.48u l=0.1u ad=0.1056p as=0.1056p pd=0.92u ps=0.92u
    I_MXI0_I2_MP3 (XI0_I2_p1_6 I0_t67_19 VDD VDD) gpdk090_pmos1v w=0.48u l=0.1u ad=0.1632p as=0.1056p pd=1.64u ps=0.92u
    I_MXI0_I2_MP0 (VDD I0_t05_17 XI0_I2_An_5 VDD) gpdk090_pmos1v w=0.24u l=0.1u ad=0.0816p as=0.0816p pd=1.16u ps=1.16u
    I_MXI0_I0_MP1 (VDD Q5_4 XI0_I0_Bn VDD) gpdk090_pmos1v w=0.24u l=0.1u ad=0.0816p as=0.0816p pd=1.16u ps=1.16u
    I_MXI0_I0_MP5 (I0_t05 XI0_I0_Bn_7 XI0_I0_p1_2 VDD) gpdk090_pmos1v w=0.48u l=0.1u ad=0.1056p as=0.1632p pd=0.92u ps=1.64u
    I_MXI0_I0_MP4 (XI0_I0_p1_4 XI0_I0_An_3 I0_t05 VDD) gpdk090_pmos1v w=0.48u l=0.1u ad=0.1056p as=0.1056p pd=0.92u ps=0.92u
    I_MXI0_I0_MP2 (VDD Q0_3 XI0_I0_p1_4 VDD) gpdk090_pmos1v w=0.48u l=0.1u ad=0.1056p as=0.1056p pd=0.92u ps=0.92u
    I_MXI0_I0_MP3 (XI0_I0_p1_6 Q5_17 VDD VDD) gpdk090_pmos1v w=0.48u l=0.1u ad=0.1632p as=0.1056p pd=1.64u ps=0.92u
    I_MXI0_I0_MP0 (VDD Q0_10 XI0_I0_An_5 VDD) gpdk090_pmos1v w=0.24u l=0.1u ad=0.0816p as=0.0816p pd=1.16u ps=1.16u
    I_MXI4_MP0 (q6n Q6_5 VDD VDD) gpdk090_pmos1v w=0.24u l=0.1u ad=0.0816p as=0.0816p pd=1.16u ps=1.16u
    I_MXI5_MP0 (VDD n01_4 a_3 VDD) gpdk090_pmos1v w=0.24u l=0.1u ad=0.0528p as=0.0816p pd=0.68u ps=1.16u
    I_MXI5_MP1 (a n23_14 VDD VDD) gpdk090_pmos1v w=0.24u l=0.1u ad=0.0816p as=0.0528p pd=1.16u ps=0.68u
    I_MXI6_MP0 (VDD n45_14 b_5 VDD) gpdk090_pmos1v w=0.24u l=0.1u ad=0.0528p as=0.0816p pd=0.68u ps=1.16u
    I_MXI6_MP1 (b q6n_11 VDD VDD) gpdk090_pmos1v w=0.24u l=0.1u ad=0.0816p as=0.0528p pd=1.16u ps=0.68u
    I_Rj1 (Q7_4 Q7_3) resistor r=54.5435
    I_Rj2 (Q7_3 Q7_5) resistor r=48.5435
    I_Rj3 (Q6_5 Q6_6) resistor r=48.5435
    I_Rj4 (Q6_6 Q6_7) resistor r=54.5435
    I_Rj5 (Q6_1 Q6_6) resistor r=10.0000
    I_Rj6 (XI0_I1_Bn_7 XI0_I1_Bn_5) resistor r=48.5435
    I_Rj7 (XI0_I1_Bn_5 XI0_I1_Bn_8) resistor r=36.5435
    I_Rj8 (Q5_4 Q5_1) resistor r=48.5435
    I_Rj9 (Q5_1 Q5_5) resistor r=54.5435
    I_Rj10 (XI0_I1_An_3 XI0_I1_An) resistor r=48.5435
    I_Rj11 (XI0_I1_An XI0_I1_An_4) resistor r=36.5435
    I_Rj12 (Q6_11 Q6_9) resistor r=48.5435
    I_Rj13 (Q6_9 Q6_12) resistor r=36.5435
    I_Rj14 (q6n_11 q6n_12) resistor r=48.5435
    I_Rj15 (q6n_12 q6n_13) resistor r=48.5435
    I_Rj16 (q6n_8 q6n_12) resistor r=10.0000
    I_Rj17 (XI0_I0_Bn_7 XI0_I0_Bn_5) resistor r=36.5435
    I_Rj18 (XI0_I0_Bn_5 XI0_I0_Bn_8) resistor r=48.5435
    I_Rj19 (Q5_12 Q5_13) resistor r=54.5435
    I_Rj20 (Q5_13 Q5_14) resistor r=36.5435
    I_Rj21 (Q5_8 Q5_13) resistor r=10.0000
    I_Rj22 (Q7_10 Q7_8) resistor r=48.5435
    I_Rj23 (Q7_8 Q7_11) resistor r=36.5435
    I_Rj24 (n45_14 n45_15) resistor r=48.5435
    I_Rj25 (n45_15 n45_16) resistor r=48.5435
    I_Rj26 (n45_10 n45_15) resistor r=10.0000
    I_Rj27 (XI0_I0_An_3 XI0_I0_An) resistor r=36.5435
    I_Rj28 (XI0_I0_An XI0_I0_An_4) resistor r=48.5435
    I_Rj29 (Q4_4 Q4_5) resistor r=54.5435
    I_Rj30 (Q4_5 Q4_6) resistor r=36.5435
    I_Rj31 (Q4_2 Q4_5) resistor r=10.0000
    I_Rj32 (Q0_3 Q0_1) resistor r=36.5435
    I_Rj33 (Q0_1 Q0_4) resistor r=48.5435
    I_Rj34 (Q6_20 Q6_21) resistor r=54.5435
    I_Rj35 (Q6_21 Q6_22) resistor r=48.5435
    I_Rj36 (Q6_16 Q6_21) resistor r=10.0000
    I_Rj37 (n23_14 n23_15) resistor r=48.5435
    I_Rj38 (n23_15 n23_16) resistor r=48.5435
    I_Rj39 (n23_11 n23_15) resistor r=10.0000
    I_Rj40 (Q5_17 Q5_15) resistor r=36.5435
    I_Rj41 (Q5_15 Q5_18) resistor r=48.5435
    I_Rj42 (Q3_4 Q3_5) resistor r=54.5435
    I_Rj43 (Q3_5 Q3_6) resistor r=36.5435
    I_Rj44 (Q3_2 Q3_5) resistor r=10.0000
    I_Rj45 (n01_4 n01_5) resistor r=48.5435
    I_Rj46 (n01_5 n01_6) resistor r=48.5435
    I_Rj47 (n01 n01_5) resistor r=10.0000
    I_Rj48 (Q2_4 Q2_5) resistor r=54.5435
    I_Rj49 (Q2_5 Q2_6) resistor r=36.5435
    I_Rj50 (Q2_1 Q2_5) resistor r=10.0000
    I_Rj51 (z_4 z_3) resistor r=54.5435
    I_Rj52 (z_3 z_5) resistor r=48.5435
    I_Rj53 (Q0_10 Q0_11) resistor r=48.5435
    I_Rj54 (Q0_11 Q0_12) resistor r=54.5435
    I_Rj55 (Q0_5 Q0_11) resistor r=10.0000
    I_Rj56 (b_13 b_12) resistor r=36.5435
    I_Rj57 (b_12 b_14) resistor r=54.5435
    I_Rj58 (Q1_4 Q1_5) resistor r=54.5435
    I_Rj59 (Q1_5 Q1_6) resistor r=36.5435
    I_Rj60 (Q1_1 Q1_5) resistor r=10.0000
    I_Rj61 (XI8_Bn_7 XI8_Bn_6) resistor r=48.5435
    I_Rj62 (XI8_Bn_6 XI8_Bn_8) resistor r=36.5435
    I_Rj63 (a_12 a_13) resistor r=36.5435
    I_Rj64 (a_13 a_14) resistor r=54.5435
    I_Rj65 (a_9 a_13) resistor r=10.0000
    I_Rj66 (I0_t67_12 I0_t67_9) resistor r=48.5435
    I_Rj67 (I0_t67_9 I0_t67_13) resistor r=54.5435
    I_Rj68 (Q0_19 Q0_20) resistor r=54.5435
    I_Rj69 (Q0_20 Q0_21) resistor r=36.5435
    I_Rj70 (Q0_15 Q0_20) resistor r=10.0000
    I_Rj71 (XI8_An_3 XI8_An) resistor r=48.5435
    I_Rj72 (XI8_An XI8_An_4) resistor r=36.5435
    I_Rj73 (tap_3 tap) resistor r=48.5435
    I_Rj74 (tap tap_4) resistor r=36.5435
    I_Rj75 (XI0_I2_Bn_7 XI0_I2_Bn_5) resistor r=36.5435
    I_Rj76 (XI0_I2_Bn_5 XI0_I2_Bn_8) resistor r=48.5435
    I_Rj77 (z_17 z_16) resistor r=48.5435
    I_Rj78 (z_16 z_18) resistor r=36.5435
    I_Rj79 (XI0_I2_An_3 XI0_I2_An) resistor r=36.5435
    I_Rj80 (XI0_I2_An XI0_I2_An_4) resistor r=48.5435
    I_Rj81 (I0_t05_11 I0_t05_9) resistor r=36.5435
    I_Rj82 (I0_t05_9 I0_t05_12) resistor r=48.5435
    I_Rj83 (tap_18 tap_19) resistor r=54.5435
    I_Rj84 (tap_19 tap_20) resistor r=48.5435
    I_Rj85 (tap_13 tap_19) resistor r=10.0000
    I_Rj86 (I0_t67_19 I0_t67_16) resistor r=36.5435
    I_Rj87 (I0_t67_16 I0_t67_20) resistor r=48.5435
    I_Rj88 (I0_t05_17 I0_t05_18) resistor r=48.5435
    I_Rj89 (I0_t05_18 I0_t05_19) resistor r=54.5435
    I_Rj90 (I0_t05_13 I0_t05_18) resistor r=10.0000
    I_Ri1 (XI0_I1_Bn XI0_I1_Bn_2) resistor r=16.8907
    I_Ri2 (Q7_1 Q7_2) resistor r=3.467E-02
    I_Ri3 (Q7_2 Q7_3) resistor r=10.0267
    I_Ri5 (Q6_1 Q6_3) resistor r=1.000E-02
    I_Ri6 (XI0_I1_Bn_3 XI0_I1_Bn_4) resistor r=16.6347
    I_Ri7 (q6n q6n_2) resistor r=15.5787
    I_Ri8 (q6n_2 q6n_4) resistor r=0.1467
    I_Ri9 (q6n_4 q6n_5) resistor r=1.4231
    I_Ri10 (q6n_3 q6n_4) resistor r=15.0000
    I_Ri11 (XI0_I1_p1 XI0_I1_p1_2) resistor r=16.4267
    I_Ri12 (XI0_I1_Bn_5 XI0_I1_Bn_6) resistor r=11.5280
    I_Ri13 (XI0_I0_Bn XI0_I0_Bn_2) resistor r=16.8907
    I_Ri14 (I0_t67 I0_t67_2) resistor r=17.0453
    I_Ri15 (Q5_1 Q5_2) resistor r=10.0267
    I_Ri16 (Q5_2 Q5_3) resistor r=3.467E-02
    I_Ri17 (XI0_I1_An XI0_I1_An_2) resistor r=11.5280
    I_Ri18 (XI0_I0_Bn_3 XI0_I0_Bn_4) resistor r=16.6347
    I_Ri19 (I0_t67_3 I0_t67_4) resistor r=1.4347
    I_Ri20 (I0_t67_4 I0_t67_5) resistor r=15.0453
    I_Ri21 (XI0_I1_p1_3 XI0_I1_p1_4) resistor r=16.4267
    I_Ri22 (b b_2) resistor r=16.5813
    I_Ri23 (Q6_9 Q6_10) resistor r=11.5813
    I_Ri24 (XI0_I0_p1 XI0_I0_p1_2) resistor r=16.4267
    I_Ri25 (n45 n45_2) resistor r=15.0800
    I_Ri26 (n45_2 n45_3) resistor r=6.667E-02
    I_Ri27 (n45_3 n45_5) resistor r=0.5752
    I_Ri28 (n45_5 n45_6) resistor r=7.179E-03
    I_Ri29 (n45_4 n45_5) resistor r=15.0000
    I_Ri30 (XI0_I0_Bn_5 XI0_I0_Bn_6) resistor r=11.5280
    I_Ri31 (q6n_8 q6n_9) resistor r=8.000E-03
    I_Ri32 (q6n_9 q6n_10) resistor r=1.4492
    I_Ri33 (Q5_8 Q5_9) resistor r=2.667E-03
    I_Ri34 (Q5_9 Q5_10) resistor r=1.4385
    I_Ri35 (Q7_7 Q7_8) resistor r=11.4267
    I_Ri36 (I0_t05 I0_t05_2) resistor r=17.0453
    I_Ri37 (n45_10 n45_11) resistor r=8.000E-03
    I_Ri38 (n45_11 n45_8) resistor r=4.267E-02
    I_Ri39 (XI0_I1_p1_6 XI0_I1_p1_5) resistor r=15.0267
    I_Ri40 (XI0_I0_An XI0_I0_An_2) resistor r=11.5280
    I_Ri42 (Q4_2 Q4_1) resistor r=1.250E-02
    I_Ri43 (b_5 b_6) resistor r=15.1520
    I_Ri44 (b_6 b_7) resistor r=2.933E-02
    I_Ri45 (b_7 b_8) resistor r=15.5440
    I_Ri46 (b_3 b_7) resistor r=1.4000
    I_Ri47 (XI0_I0_p1_3 XI0_I0_p1_4) resistor r=16.4267
    I_Ri48 (I0_t05_5 I0_t05_6) resistor r=15.0453
    I_Ri49 (I0_t05_6 I0_t05_3) resistor r=1.4347
    I_Ri50 (n45_13 n45_12) resistor r=15.0800
    I_Ri51 (XI0_I1_An_5 XI0_I1_An_6) resistor r=16.8907
    I_Ri52 (Q0_1 Q0_2) resistor r=11.5813
    I_Ri53 (a a_2) resistor r=16.5813
    I_Ri54 (Q6_16 Q6_17) resistor r=6.133E-02
    I_Ri55 (Q6_17 Q6_18) resistor r=1.5200
    I_Ri56 (n23_3 n23_4) resistor r=15.0800
    I_Ri57 (n23_4 n23_5) resistor r=6.667E-02
    I_Ri58 (n23_5 n23_7) resistor r=0.5773
    I_Ri59 (n23_7 n23_8) resistor r=7.368E-03
    I_Ri60 (n23_6 n23_7) resistor r=15.0000
    I_Ri61 (XI0_I1_An_7 XI0_I1_An_8) resistor r=16.6347
    I_Ri62 (Q5_15 Q5_16) resistor r=11.4267
    I_Ri63 (n23_10 n23_11) resistor r=1.4008
    I_Ri65 (Q3_2 Q3_3) resistor r=2.667E-03
    I_Ri66 (Q3_3 Q3_1) resistor r=3.714E-02
    I_Ri67 (XI0_I0_p1_5 XI0_I0_p1_6) resistor r=16.4267
    I_Ri68 (n01 n01_2) resistor r=8.000E-03
    I_Ri69 (n01_2 n01_3) resistor r=4.267E-02
    I_Ri70 (XI8_Bn XI8_Bn_2) resistor r=16.8907
    I_Ri71 (Q2_1 Q2_2) resistor r=2.667E-03
    I_Ri72 (Q2_2 Q2_3) resistor r=1.4400
    I_Ri73 (a_3 a_4) resistor r=15.1520
    I_Ri74 (a_4 a_5) resistor r=2.933E-02
    I_Ri75 (a_5 a_6) resistor r=15.5440
    I_Ri76 (z z_2) resistor r=3.467E-02
    I_Ri77 (z_2 z_3) resistor r=10.0267
    I_Ri78 (XI0_I0_An_5 XI0_I0_An_6) resistor r=16.8907
    I_Ri79 (n23_17 n23_18) resistor r=16.4800
    I_Ri80 (XI8_Bn_3 XI8_Bn_4) resistor r=16.6347
    I_Ri81 (Q0_5 Q0_6) resistor r=6.133E-02
    I_Ri82 (Q0_6 Q0_7) resistor r=1.5200
    I_Ri83 (z_6 z_7) resistor r=15.5787
    I_Ri84 (z_7 z_8) resistor r=6.667E-02
    I_Ri85 (z_8 z_9) resistor r=15.0800
    I_Ri86 (XI0_I0_An_7 XI0_I0_An_8) resistor r=16.6347
    I_Ri87 (n01_11 n01_12) resistor r=15.0800
    I_Ri88 (n01_12 n01_13) resistor r=6.667E-02
    I_Ri89 (n01_13 n01_14) resistor r=0.1156
    I_Ri90 (n01_14 n01_15) resistor r=15.4276
    I_Ri91 (XI8_p1 XI8_p1_2) resistor r=16.4267
    I_Ri92 (b_10 b_11) resistor r=5.333E-02
    I_Ri93 (b_11 b_12) resistor r=10.0027
    I_Ri94 (Q1_1 Q1_2) resistor r=2.667E-03
    I_Ri95 (Q1_2 Q1_3) resistor r=1.4385
    I_Ri96 (XI8_Bn_6 XI8_Bn_5) resistor r=10.1280
    I_Ri97 (XI0_I2_Bn XI0_I2_Bn_2) resistor r=16.8907
    I_Ri98 (FB_2 FB_3) resistor r=17.0453
    I_Ri99 (I0_t67_9 I0_t67_10) resistor r=10.0267
    I_Ri100 (I0_t67_10 I0_t67_11) resistor r=3.467E-02
    I_Ri102 (a_9 a_11) resistor r=3.333E-03
    I_Ri103 (Q0_15 Q0_16) resistor r=2.667E-03
    I_Ri104 (Q0_16 Q0_17) resistor r=1.4400
    I_Ri105 (z_12 z_13) resistor r=16.4800
    I_Ri106 (XI8_An XI8_An_2) resistor r=11.5280
    I_Ri107 (XI0_I2_Bn_3 XI0_I2_Bn_4) resistor r=16.6347
    I_Ri108 (n01_16 n01_17) resistor r=16.4800
    I_Ri109 (FB_4 FB_5) resistor r=1.4347
    I_Ri110 (FB_5 FB_6) resistor r=15.0453
    I_Ri111 (XI8_p1_3 XI8_p1_4) resistor r=16.4267
    I_Ri112 (tap tap_2) resistor r=11.5813
    I_Ri113 (XI0_I2_p1 XI0_I2_p1_2) resistor r=16.4267
    I_Ri114 (XI0_I2_Bn_5 XI0_I2_Bn_6) resistor r=11.5280
    I_Ri115 (z_15 z_16) resistor r=10.0267
    I_Ri116 (tap_5 tap_6) resistor r=17.0453
    I_Ri117 (XI8_p1_5 XI8_p1_6) resistor r=16.4267
    I_Ri118 (XI0_I2_An XI0_I2_An_2) resistor r=11.5280
    I_Ri119 (XI0_I2_p1_3 XI0_I2_p1_4) resistor r=16.4267
    I_Ri120 (tap_7 tap_8) resistor r=15.0453
    I_Ri121 (tap_8 tap_9) resistor r=1.4347
    I_Ri122 (XI8_An_5 XI8_An_6) resistor r=16.8907
    I_Ri123 (I0_t05_9 I0_t05_10) resistor r=11.5813
    I_Ri124 (tap_13 tap_14) resistor r=6.133E-02
    I_Ri125 (tap_14 tap_15) resistor r=1.5200
    I_Ri126 (XI8_An_7 XI8_An_8) resistor r=16.6347
    I_Ri127 (I0_t67_16 I0_t67_17) resistor r=11.4267
    I_Ri128 (XI0_I2_p1_5 XI0_I2_p1_6) resistor r=15.0267
    I_Ri129 (XI0_I2_An_5 XI0_I2_An_6) resistor r=16.8907
    I_Ri130 (I0_t05_13 I0_t05_14) resistor r=6.133E-02
    I_Ri131 (I0_t05_14 I0_t05_15) resistor r=1.5200
    I_Ri132 (XI0_I2_An_7 XI0_I2_An_8) resistor r=16.6347
    I_Rh1 (Q6_4 Q6_3) resistor r=2.9341
    I_Rh2 (q6n_6 q6n_5) resistor r=1.5019
    I_Rh3 (XI0_I1_Bn_6 XI0_I1_Bn_4) resistor r=0.3240
    I_Rh4 (XI0_I1_Bn_4 XI0_I1_Bn_2) resistor r=0.2160
    I_Rh5 (Q6 Q6_8) resistor r=3.1268
    I_Rh6 (I0_t67_3 I0_t67_6) resistor r=5.992E-02
    I_Rh7 (I0_t67_6 I0_t67_2) resistor r=0.1519
    I_Rh8 (I0_t67_6 I0_t67_7) resistor r=1.5790
    I_Rh9 (q6n_10 q6n_7) resistor r=0.3938
    I_Rh10 (XI0_I0_Bn_6 XI0_I0_Bn_4) resistor r=0.3240
    I_Rh11 (XI0_I0_Bn_4 XI0_I0_Bn_2) resistor r=0.2160
    I_Rh12 (Q5 Q5_11) resistor r=1.8009
    I_Rh13 (Q5_11 Q5_7) resistor r=0.8642
    I_Rh14 (Q5_11 Q5_10) resistor r=0.2900
    I_Rh15 (n45_7 n45_6) resistor r=2.9641
    I_Rh16 (Q7_7 Q7_9) resistor r=1.0800
    I_Rh17 (Q7_9 Q7_6) resistor r=0.1513
    I_Rh18 (Q7_2 Q7_9) resistor r=1.4000
    I_Rh19 (n45_8 n45_9) resistor r=3.5386
    I_Rh20 (Q4 Q4_1) resistor r=3.1997
    I_Rh21 (XI0_I1_p1_5 XI0_I1_p1_4) resistor r=1.8320
    I_Rh22 (XI0_I1_p1_4 XI0_I1_p1_2) resistor r=0.4320
    I_Rh23 (b_2 b_3) resistor r=0.4320
    I_Rh24 (b_3 b_4) resistor r=1.6027
    I_Rh25 (I0_t05_2 I0_t05_3) resistor r=0.2160
    I_Rh26 (I0_t05_3 I0_t05_4) resistor r=1.5984
    I_Rh27 (n45_12 n45_2) resistor r=3.2320
    I_Rh28 (n23_9 n23_8) resistor r=3.1658
    I_Rh29 (Q6_18 Q6_19) resistor r=0.1199
    I_Rh30 (Q6_19 Q6_10) resistor r=0.5239
    I_Rh31 (Q6_19 Q6_15) resistor r=0.1362
    I_Rh32 (n23_10 n23_13) resistor r=1.8901
    I_Rh33 (Q5_16 Q5_6) resistor r=0.9121
    I_Rh34 (Q5_6 Q5_2) resistor r=1.5401
    I_Rh35 (XI0_I1_An_8 XI0_I1_An_6) resistor r=0.2160
    I_Rh36 (XI0_I1_An_6 XI0_I1_An_2) resistor r=0.7560
    I_Rh37 (Q3 Q3_1) resistor r=3.2217
    I_Rh38 (XI0_I0_p1_5 XI0_I0_p1_3) resistor r=0.4320
    I_Rh39 (XI0_I0_p1_3 XI0_I0_p1) resistor r=0.4320
    I_Rh40 (Q2 Q2_3) resistor r=1.7997
    I_Rh41 (n23_18 n23_4) resistor r=1.8320
    I_Rh42 (n01_7 n01_3) resistor r=3.6760
    I_Rh43 (a_7 a_8) resistor r=1.4144
    I_Rh44 (a_7 a_2) resistor r=0.4320
    I_Rh45 (a_5 a_7) resistor r=1.4000
    I_Rh46 (Q0 Q0_8) resistor r=2.7025
    I_Rh47 (Q0_7 Q0_9) resistor r=1.4182
    I_Rh48 (Q0_7 Q0_2) resistor r=0.6480
    I_Rh49 (n01_14 n01_9) resistor r=1.5534
    I_Rh50 (XI0_I0_An_8 XI0_I0_An_6) resistor r=0.2160
    I_Rh51 (XI0_I0_An_6 XI0_I0_An_2) resistor r=0.7560
    I_Rh52 (b_10 b_9) resistor r=1.6005
    I_Rh53 (Q1 Q1_3) resistor r=1.7893
    I_Rh54 (XI8_Bn_5 XI8_Bn_4) resistor r=1.7240
    I_Rh55 (XI8_Bn_4 XI8_Bn_2) resistor r=0.2160
    I_Rh56 (FB FB_1) resistor r=2.8782
    I_Rh57 (Q0_17 Q0_18) resistor r=1.7658
    I_Rh58 (z_13 z_14) resistor r=0.2719
    I_Rh59 (z_14 z_8) resistor r=1.5559
    I_Rh60 (z_14 z_10) resistor r=0.5648
    I_Rh61 (n01_17 n01_12) resistor r=1.8320
    I_Rh62 (a_15 a_11) resistor r=1.5641
    I_Rh63 (FB_3 FB_4) resistor r=0.2160
    I_Rh64 (FB_4 FB_7) resistor r=2.6536
    I_Rh65 (XI0_I2_Bn_6 XI0_I2_Bn_4) resistor r=0.3240
    I_Rh66 (XI0_I2_Bn_4 XI0_I2_Bn_2) resistor r=0.2160
    I_Rh67 (z_15 z_11) resistor r=2.0930
    I_Rh68 (z_11 z_2) resistor r=1.7610
    I_Rh69 (XI8_p1_6 XI8_p1_4) resistor r=0.4320
    I_Rh70 (XI8_p1_4 XI8_p1_2) resistor r=0.4320
    I_Rh71 (tap_9 tap_10) resistor r=0.1079
    I_Rh72 (tap_10 tap_6) resistor r=0.1039
    I_Rh73 (tap_10 tap_11) resistor r=1.5876
    I_Rh74 (tap_15 tap_16) resistor r=9.192E-02
    I_Rh75 (tap_16 tap_2) resistor r=0.5519
    I_Rh76 (tap_16 tap_17) resistor r=2.0333
    I_Rh77 (I0_t67_17 I0_t67_18) resistor r=1.0119
    I_Rh78 (I0_t67_18 I0_t67_10) resistor r=1.4639
    I_Rh79 (I0_t67_18 I0_t67_14) resistor r=0.7490
    I_Rh80 (XI8_An_8 XI8_An_6) resistor r=0.2160
    I_Rh81 (XI8_An_6 XI8_An_2) resistor r=0.7560
    I_Rh82 (XI0_I2_p1_5 XI0_I2_p1_3) resistor r=1.8320
    I_Rh83 (XI0_I2_p1_3 XI0_I2_p1) resistor r=0.4320
    I_Rh84 (I0_t05_15 I0_t05_16) resistor r=0.1561
    I_Rh85 (I0_t05_16 I0_t05_10) resistor r=0.4641
    I_Rh86 (XI0_I2_An_8 XI0_I2_An_6) resistor r=0.2160
    I_Rh87 (XI0_I2_An_6 XI0_I2_An_2) resistor r=0.7560
    I_Rg1 (Q7 Q7_6) resistor r=3.6454
    I_Rg2 (Q5_6 Q5_7) resistor r=3.1505
    I_Rg3 (q6n_7 q6n_6) resistor r=1.8901
    I_Rg4 (Q6_13 Q6_8) resistor r=1.6415
    I_Rg5 (Q6_8 Q6_4) resistor r=0.4901
    I_Rg6 (n45_17 n45_9) resistor r=1.6415
    I_Rg7 (Q6_15 Q6_14) resistor r=1.8901
    I_Rg8 (n45_18 n45_7) resistor r=1.7658
    I_Rg9 (n23_9 n23_2) resistor r=0.2415
    I_Rg10 (n23_13 n23) resistor r=0.3658
    I_Rg11 (n01_7 n01_8) resistor r=1.6415
    I_Rg12 (n01_9 n01_10) resistor r=3.0415
    I_Rg13 (Q0_9 Q0_13) resistor r=1.5019
    I_Rg14 (b_9 b_4) resistor r=2.2629
    I_Rg15 (z_10 z_11) resistor r=3.1355
    I_Rg16 (I0_t67_8 I0_t67_7) resistor r=3.1329
    I_Rg17 (Q0_18 Q0_14) resistor r=0.4278
    I_Rg18 (Q0_14 Q0_8) resistor r=0.1035
    I_Rg19 (I0_t67_14 I0_t67_15) resistor r=3.0415
    I_Rg20 (a_15 a_8) resistor r=2.2100
    I_Rg21 (FB_7 FB_1) resistor r=0.3658
    I_Rg22 (I0_t05_7 I0_t05_4) resistor r=3.0086
    I_Rg23 (tap_12 tap_11) resistor r=1.5019
    I_Rg24 (tap_17 tap_21) resistor r=1.6415
    I_Rg25 (I0_t05_16 I0_t05_8) resistor r=2.5115
    I_Rf1 (Q6_13 Q6_14) resistor r=2.8844
    I_Rf2 (n23 n23_2) resistor r=5.6515
    I_Rf3 (n45_17 n45_18) resistor r=2.9758
    I_Rf4 (n01_8 n01_10) resistor r=2.6029
    I_Rf5 (Q0_13 Q0_14) resistor r=3.0086
    I_Rf6 (I0_t67_8 I0_t67_15) resistor r=0.8629
    I_Rf7 (I0_t05_8 I0_t05_7) resistor r=2.0144
    I_Rf8 (tap_21 tap_12) resistor r=0.7386
    I_C1 (VDD GND) capacitor c=1.006E-14
    I_C2 (FB GND) capacitor c=1.604E-16
    I_C3 (Q0 GND) capacitor c=1.950E-16
    I_C4 (Q1 GND) capacitor c=2.267E-16
    I_C5 (Q2 GND) capacitor c=2.579E-16
    I_C6 (Q3 GND) capacitor c=2.237E-16
    I_C7 (Q4 GND) capacitor c=2.046E-16
    I_C8 (Q5 GND) capacitor c=2.007E-16
    I_C9 (Q6 GND) capacitor c=1.876E-16
    I_C10 (Q7 GND) capacitor c=2.373E-16
    I_C11 (n45 GND) capacitor c=2.879E-17
    I_C12 (q6n GND) capacitor c=8.450E-17
    I_C13 (b GND) capacitor c=3.813E-17
    I_C14 (n01 GND) capacitor c=6.594E-17
    I_C15 (n23 GND) capacitor c=5.067E-16
    I_C16 (a GND) capacitor c=4.049E-17
    I_C17 (I0_t05 GND) capacitor c=1.179E-16
    I_C18 (I0_t67 GND) capacitor c=1.217E-16
    I_C19 (tap GND) capacitor c=9.687E-17
    I_C20 (z GND) capacitor c=1.077E-16
    I_C21 (XI7_p1 GND) capacitor c=1.007E-17
    I_C22 (XI1_p1 GND) capacitor c=3.845E-18
    I_C23 (XI2_p1 GND) capacitor c=1.291E-18
    I_C24 (XI3_p1 GND) capacitor c=9.352E-18
    I_C25 (XI8_p1 GND) capacitor c=5.876E-18
    I_C26 (XI8_n2 GND) capacitor c=7.131E-18
    I_C27 (XI8_An GND) capacitor c=1.059E-16
    I_C28 (XI8_Bn GND) capacitor c=8.070E-17
    I_C29 (XI0_I1_n1 GND) capacitor c=3.820E-19
    I_C30 (XI0_I1_n2 GND) capacitor c=8.239E-18
    I_C31 (XI0_I1_An GND) capacitor c=1.063E-16
    I_C32 (XI0_I1_Bn GND) capacitor c=8.132E-17
    I_C33 (XI0_I2_p1 GND) capacitor c=1.535E-16
    I_C34 (XI0_I2_n2 GND) capacitor c=1.039E-17
    I_C35 (XI0_I2_An GND) capacitor c=1.063E-16
    I_C36 (XI0_I2_Bn GND) capacitor c=8.311E-17
    I_C37 (XI0_I0_p1 GND) capacitor c=1.306E-16
    I_C38 (XI0_I0_n2 GND) capacitor c=7.826E-18
    I_C39 (XI0_I0_An GND) capacitor c=1.063E-16
    I_C40 (XI0_I0_Bn GND) capacitor c=7.090E-17
    I_C41 (XI5_n1 GND) capacitor c=1.014E-18
    I_C42 (XI6_n1 GND) capacitor c=6.315E-19
    I_C43 (I0_t05_17 GND) capacitor c=6.769E-17
    I_C44 (I0_t67_19 GND) capacitor c=6.766E-17
    I_C45 (tap_20 GND) capacitor c=4.830E-17
    I_C46 (I0_t05_11 GND) capacitor c=5.484E-17
    I_C47 (XI0_I2_An_3 GND) capacitor c=6.426E-17
    I_C48 (z_18 GND) capacitor c=6.110E-17
    I_C49 (XI0_I2_Bn_7 GND) capacitor c=6.385E-17
    I_C50 (tap_4 GND) capacitor c=5.761E-17
    I_C51 (XI8_An_4 GND) capacitor c=6.801E-17
    I_C52 (a_12 GND) capacitor c=4.776E-17
    I_C53 (I0_t67_12 GND) capacitor c=5.328E-17
    I_C54 (Q0_21 GND) capacitor c=4.685E-17
    I_C55 (XI8_Bn_8 GND) capacitor c=6.148E-17
    I_C56 (b_13 GND) capacitor c=5.879E-17
    I_C57 (Q1_6 GND) capacitor c=4.980E-17
    I_C58 (Q0_10 GND) capacitor c=6.746E-17
    I_C59 (z_5 GND) capacitor c=5.689E-17
    I_C60 (n01_4 GND) capacitor c=6.078E-17
    I_C61 (Q2_6 GND) capacitor c=4.130E-17
    I_C62 (n23_14 GND) capacitor c=5.904E-17
    I_C63 (Q5_17 GND) capacitor c=5.991E-17
    I_C64 (Q3_6 GND) capacitor c=4.995E-17
    I_C65 (Q6_22 GND) capacitor c=5.521E-17
    I_C66 (Q0_3 GND) capacitor c=5.484E-17
    I_C67 (n45_14 GND) capacitor c=6.055E-17
    I_C68 (XI0_I0_An_3 GND) capacitor c=6.562E-17
    I_C69 (Q4_6 GND) capacitor c=4.952E-17
    I_C70 (Q7_11 GND) capacitor c=5.940E-17
    I_C71 (q6n_11 GND) capacitor c=5.328E-17
    I_C72 (XI0_I0_Bn_7 GND) capacitor c=6.510E-17
    I_C73 (Q5_14 GND) capacitor c=4.099E-17
    I_C74 (Q6_12 GND) capacitor c=6.061E-17
    I_C75 (XI0_I1_An_4 GND) capacitor c=6.674E-17
    I_C76 (Q5_4 GND) capacitor c=6.030E-17
    I_C77 (XI0_I1_Bn_8 GND) capacitor c=6.465E-17
    I_C78 (Q6_5 GND) capacitor c=5.431E-17
    I_C79 (Q7_5 GND) capacitor c=5.819E-17
    I_C80 (I0_t05_19 GND) capacitor c=6.369E-17
    I_C81 (I0_t67_20 GND) capacitor c=5.897E-17
    I_C82 (tap_18 GND) capacitor c=5.739E-17
    I_C83 (I0_t05_12 GND) capacitor c=5.715E-17
    I_C84 (XI0_I2_An_4 GND) capacitor c=4.898E-17
    I_C85 (z_17 GND) capacitor c=5.854E-17
    I_C86 (XI0_I2_Bn_8 GND) capacitor c=5.339E-17
    I_C87 (tap_3 GND) capacitor c=5.556E-17
    I_C88 (XI8_An_3 GND) capacitor c=5.113E-17
    I_C89 (a_14 GND) capacitor c=5.412E-17
    I_C90 (I0_t67_13 GND) capacitor c=5.091E-17
    I_C91 (Q0_19 GND) capacitor c=5.559E-17
    I_C92 (XI8_Bn_7 GND) capacitor c=5.911E-17
    I_C93 (b_14 GND) capacitor c=5.484E-17
    I_C94 (Q1_4 GND) capacitor c=5.480E-17
    I_C95 (Q0_12 GND) capacitor c=5.623E-17
    I_C96 (z_4 GND) capacitor c=5.352E-17
    I_C97 (n01_6 GND) capacitor c=4.287E-17
    I_C98 (Q2_4 GND) capacitor c=5.417E-17
    I_C99 (n23_16 GND) capacitor c=5.234E-17
    I_C100 (Q5_18 GND) capacitor c=5.721E-17
    I_C101 (Q3_4 GND) capacitor c=5.451E-17
    I_C102 (Q6_20 GND) capacitor c=5.305E-17
    I_C103 (Q0_4 GND) capacitor c=5.544E-17
    I_C104 (n45_16 GND) capacitor c=5.010E-17
    I_C105 (XI0_I0_An_4 GND) capacitor c=5.265E-17
    I_C106 (Q4_4 GND) capacitor c=5.367E-17
    I_C107 (Q7_10 GND) capacitor c=5.673E-17
    I_C108 (q6n_13 GND) capacitor c=4.140E-17
    I_C109 (XI0_I0_Bn_8 GND) capacitor c=5.656E-17
    I_C110 (Q5_12 GND) capacitor c=4.987E-17
    I_C111 (Q6_11 GND) capacitor c=5.355E-17
    I_C112 (XI0_I1_An_3 GND) capacitor c=5.529E-17
    I_C113 (Q5_5 GND) capacitor c=5.485E-17
    I_C114 (XI0_I1_Bn_7 GND) capacitor c=5.686E-17
    I_C115 (Q6_7 GND) capacitor c=5.422E-17
    I_C116 (Q7_4 GND) capacitor c=5.622E-17
    I_C117 (I0_t05_16 GND) capacitor c=1.947E-16
    I_C118 (tap_17 GND) capacitor c=1.270E-16
    I_C119 (tap_11 GND) capacitor c=6.755E-17
    I_C120 (FB_7 GND) capacitor c=2.059E-16
    I_C121 (a_15 GND) capacitor c=1.596E-16
    I_C122 (I0_t67_14 GND) capacitor c=1.236E-16
    I_C123 (Q0_18 GND) capacitor c=1.016E-16
    I_C124 (FB_1 GND) capacitor c=2.034E-16
    I_C125 (z_10 GND) capacitor c=1.763E-16
    I_C126 (z_11 GND) capacitor c=3.045E-16
    I_C127 (b_9 GND) capacitor c=1.696E-16
    I_C128 (Q0_9 GND) capacitor c=2.038E-17
    I_C129 (Q0_8 GND) capacitor c=2.177E-16
    I_C130 (a_8 GND) capacitor c=8.416E-17
    I_C131 (n01_7 GND) capacitor c=2.002E-16
    I_C132 (n01_9 GND) capacitor c=8.818E-17
    I_C133 (n23_13 GND) capacitor c=1.400E-16
    I_C134 (n23_9 GND) capacitor c=9.286E-17
    I_C135 (Q6_15 GND) capacitor c=1.050E-16
    I_C136 (b_4 GND) capacitor c=1.260E-16
    I_C137 (I0_t05_4 GND) capacitor c=2.131E-16
    I_C138 (n45_9 GND) capacitor c=1.799E-16
    I_C139 (n45_7 GND) capacitor c=1.063E-16
    I_C140 (q6n_7 GND) capacitor c=1.172E-16
    I_C141 (Q6_8 GND) capacitor c=2.246E-16
    I_C142 (I0_t67_7 GND) capacitor c=3.213E-16
    I_C143 (Q5_6 GND) capacitor c=2.557E-16
    I_C144 (Q5_7 GND) capacitor c=1.314E-16
    I_C145 (q6n_6 GND) capacitor c=7.358E-17
    I_C146 (Q6_4 GND) capacitor c=6.940E-17
    I_C147 (Q7_6 GND) capacitor c=1.517E-16
    I_C148 (I0_t05_13 GND) capacitor c=6.781E-17
    I_C149 (I0_t67_16 GND) capacitor c=5.366E-17
    I_C150 (tap_13 GND) capacitor c=6.389E-17
    I_C151 (I0_t05_9 GND) capacitor c=9.680E-17
    I_C152 (z_16 GND) capacitor c=5.257E-17
    I_C153 (XI0_I2_Bn_5 GND) capacitor c=1.004E-16
    I_C154 (a_9 GND) capacitor c=1.064E-16
    I_C155 (I0_t67_9 GND) capacitor c=6.455E-17
    I_C156 (Q0_15 GND) capacitor c=5.429E-17
    I_C157 (XI8_Bn_6 GND) capacitor c=1.009E-16
    I_C158 (b_12 GND) capacitor c=6.242E-17
    I_C159 (Q1_1 GND) capacitor c=6.422E-17
    I_C160 (Q0_5 GND) capacitor c=6.882E-17
    I_C161 (z_3 GND) capacitor c=6.926E-17
    I_C162 (Q2_1 GND) capacitor c=6.140E-17
    I_C163 (n23_11 GND) capacitor c=1.525E-16
    I_C164 (Q5_15 GND) capacitor c=5.469E-17
    I_C165 (Q3_2 GND) capacitor c=6.175E-17
    I_C166 (Q6_16 GND) capacitor c=6.764E-17
    I_C167 (Q0_1 GND) capacitor c=9.538E-17
    I_C168 (n45_10 GND) capacitor c=7.220E-17
    I_C169 (Q4_2 GND) capacitor c=1.359E-16
    I_C170 (Q7_8 GND) capacitor c=5.471E-17
    I_C171 (q6n_8 GND) capacitor c=5.133E-17
    I_C172 (XI0_I0_Bn_5 GND) capacitor c=1.016E-16
    I_C173 (Q5_8 GND) capacitor c=6.034E-17
    I_C174 (Q6_9 GND) capacitor c=9.573E-17
    I_C175 (Q5_1 GND) capacitor c=6.226E-17
    I_C176 (XI0_I1_Bn_5 GND) capacitor c=1.010E-16
    I_C177 (Q6_1 GND) capacitor c=5.281E-17
    I_C178 (Q7_3 GND) capacitor c=6.071E-17
    I_C179 (tap_21 GND) capacitor c=1.006E-16
    I_C180 (tap_12 GND) capacitor c=7.364E-17
    I_C181 (I0_t05_8 GND) capacitor c=1.956E-16
    I_C182 (I0_t05_7 GND) capacitor c=2.108E-16
    I_C183 (I0_t67_8 GND) capacitor c=3.448E-16
    I_C184 (I0_t67_15 GND) capacitor c=9.759E-17
    I_C185 (Q0_13 GND) capacitor c=1.442E-16
    I_C186 (Q0_14 GND) capacitor c=1.447E-16
    I_C187 (n01_8 GND) capacitor c=2.400E-16
    I_C188 (n01_10 GND) capacitor c=2.654E-16
    I_C189 (n45_17 GND) capacitor c=5.637E-16
    I_C190 (n45_18 GND) capacitor c=4.714E-16
    I_C191 (n23_2 GND) capacitor c=4.752E-16
    I_C192 (Q6_13 GND) capacitor c=1.278E-16
    I_C193 (Q6_14 GND) capacitor c=1.810E-16
    I_C194 (XI0_I2_An_8 GND) capacitor c=7.807E-17
    I_C195 (I0_t05_15 GND) capacitor c=7.173E-17
    I_C196 (XI0_I2_An_6 GND) capacitor c=2.177E-16
    I_C197 (XI0_I2_p1_5 GND) capacitor c=1.761E-16
    I_C198 (XI8_An_8 GND) capacitor c=7.824E-17
    I_C199 (I0_t67_17 GND) capacitor c=3.697E-16
    I_C200 (tap_15 GND) capacitor c=7.247E-17
    I_C201 (XI8_An_6 GND) capacitor c=2.089E-16
    I_C202 (I0_t05_10 GND) capacitor c=2.055E-16
    I_C203 (XI0_I2_p1_3 GND) capacitor c=2.430E-16
    I_C204 (tap_9 GND) capacitor c=4.692E-17
    I_C205 (XI8_p1_6 GND) capacitor c=1.749E-16
    I_C206 (XI0_I2_An_2 GND) capacitor c=2.800E-16
    I_C207 (z_15 GND) capacitor c=2.923E-16
    I_C208 (tap_6 GND) capacitor c=1.799E-16
    I_C209 (XI0_I2_Bn_6 GND) capacitor c=1.409E-16
    I_C210 (tap_2 GND) capacitor c=2.461E-16
    I_C211 (FB_4 GND) capacitor c=1.940E-16
    I_C212 (XI8_p1_4 GND) capacitor c=2.205E-16
    I_C213 (z_13 GND) capacitor c=7.849E-17
    I_C214 (XI8_An_2 GND) capacitor c=2.765E-16
    I_C215 (XI0_I2_Bn_4 GND) capacitor c=1.416E-16
    I_C216 (n01_17 GND) capacitor c=9.040E-17
    I_C217 (a_11 GND) capacitor c=3.501E-17
    I_C218 (Q0_17 GND) capacitor c=5.501E-17
    I_C219 (FB_3 GND) capacitor c=2.144E-16
    I_C220 (I0_t67_10 GND) capacitor c=4.261E-17
    I_C221 (XI8_Bn_5 GND) capacitor c=1.548E-16
    I_C222 (XI0_I2_Bn_2 GND) capacitor c=1.594E-16
    I_C223 (b_10 GND) capacitor c=5.784E-17
    I_C224 (Q1_3 GND) capacitor c=2.486E-16
    I_C225 (XI8_p1_2 GND) capacitor c=1.481E-16
    I_C226 (z_8 GND) capacitor c=1.690E-16
    I_C227 (XI0_I0_An_8 GND) capacitor c=8.949E-17
    I_C228 (n01_12 GND) capacitor c=5.845E-17
    I_C229 (n01_14 GND) capacitor c=1.262E-16
    I_C230 (XI8_Bn_4 GND) capacitor c=1.495E-16
    I_C231 (Q0_7 GND) capacitor c=1.451E-16
    I_C232 (z_2 GND) capacitor c=9.465E-17
    I_C233 (XI0_I0_An_6 GND) capacitor c=2.368E-16
    I_C234 (n23_18 GND) capacitor c=1.153E-16
    I_C235 (Q2_3 GND) capacitor c=2.569E-16
    I_C236 (XI8_Bn_2 GND) capacitor c=1.612E-16
    I_C237 (n01_3 GND) capacitor c=1.610E-16
    I_C238 (XI0_I0_p1_5 GND) capacitor c=1.738E-16
    I_C239 (Q3_1 GND) capacitor c=2.859E-16
    I_C240 (n23_10 GND) capacitor c=6.861E-17
    I_C241 (XI0_I1_An_8 GND) capacitor c=9.136E-17
    I_C242 (Q5_16 GND) capacitor c=3.593E-16
    I_C243 (a_2 GND) capacitor c=1.160E-16
    I_C244 (Q6_18 GND) capacitor c=7.487E-17
    I_C245 (n23_4 GND) capacitor c=5.815E-17
    I_C246 (n23_8 GND) capacitor c=1.537E-16
    I_C247 (XI0_I1_An_6 GND) capacitor c=2.536E-16
    I_C248 (Q0_2 GND) capacitor c=2.734E-16
    I_C249 (b_3 GND) capacitor c=6.732E-17
    I_C250 (XI0_I0_p1_3 GND) capacitor c=2.135E-16
    I_C251 (I0_t05_3 GND) capacitor c=7.342E-17
    I_C252 (n45_12 GND) capacitor c=9.190E-17
    I_C253 (XI0_I1_p1_5 GND) capacitor c=1.858E-16
    I_C254 (XI0_I0_An_2 GND) capacitor c=2.874E-16
    I_C255 (n45_8 GND) capacitor c=1.017E-16
    I_C256 (Q4_1 GND) capacitor c=2.269E-16
    I_C257 (Q7_7 GND) capacitor c=3.916E-16
    I_C258 (I0_t05_2 GND) capacitor c=2.065E-16
    I_C259 (Q5_10 GND) capacitor c=7.145E-17
    I_C260 (q6n_10 GND) capacitor c=8.081E-17
    I_C261 (XI0_I0_Bn_6 GND) capacitor c=1.321E-16
    I_C262 (n45_6 GND) capacitor c=1.087E-16
    I_C263 (b_2 GND) capacitor c=1.313E-16
    I_C264 (Q6_10 GND) capacitor c=2.289E-16
    I_C265 (n45_2 GND) capacitor c=6.138E-17
    I_C266 (I0_t67_3 GND) capacitor c=4.064E-17
    I_C267 (XI0_I1_p1_4 GND) capacitor c=2.155E-16
    I_C268 (XI0_I1_An_2 GND) capacitor c=2.834E-16
    I_C269 (XI0_I0_Bn_4 GND) capacitor c=1.470E-16
    I_C270 (I0_t67_2 GND) capacitor c=1.966E-16
    I_C271 (Q5_2 GND) capacitor c=5.053E-17
    I_C272 (XI0_I1_Bn_6 GND) capacitor c=1.317E-16
    I_C273 (XI0_I0_Bn_2 GND) capacitor c=1.529E-16
    I_C274 (XI0_I1_p1_2 GND) capacitor c=1.278E-16
    I_C275 (q6n_5 GND) capacitor c=6.527E-17
    I_C276 (XI0_I1_Bn_4 GND) capacitor c=1.253E-16
    I_C277 (Q6_3 GND) capacitor c=1.239E-16
    I_C278 (Q7_2 GND) capacitor c=2.361E-16
    I_C279 (XI0_I1_Bn_2 GND) capacitor c=1.582E-16
    I_C280 (XI0_I2_An_5 GND) capacitor c=1.127E-16
    I_C281 (XI0_I2_p1_6 GND) capacitor c=1.260E-18
    I_C282 (XI8_An_5 GND) capacitor c=1.080E-16
    I_C283 (XI0_I2_p1_4 GND) capacitor c=1.721E-18
    I_C284 (XI8_p1_5 GND) capacitor c=3.376E-20
    I_C285 (tap_5 GND) capacitor c=1.172E-16
    I_C286 (XI8_p1_3 GND) capacitor c=1.393E-18
    I_C287 (FB_2 GND) capacitor c=1.212E-16
    I_C288 (z_6 GND) capacitor c=8.437E-17
    I_C289 (n01_15 GND) capacitor c=6.925E-17
    I_C290 (XI0_I0_An_5 GND) capacitor c=1.100E-16
    I_C291 (a_3 GND) capacitor c=3.375E-17
    I_C292 (n23_6 GND) capacitor c=4.929E-19
    I_C293 (XI0_I1_An_5 GND) capacitor c=1.011E-16
    I_C294 (XI0_I0_p1_4 GND) capacitor c=1.188E-18
    I_C295 (b_5 GND) capacitor c=3.379E-17
    I_C296 (XI0_I0_p1_2 GND) capacitor c=1.964E-20
    I_C297 (XI0_I1_p1_3 GND) capacitor c=1.382E-18
    I_C298 (XI0_I2_An_7 GND) capacitor c=3.881E-17
    I_C299 (XI8_An_7 GND) capacitor c=3.467E-17
    I_C300 (z_12 GND) capacitor c=3.748E-17
    I_C301 (XI0_I2_Bn_3 GND) capacitor c=4.345E-17
    I_C302 (n01_16 GND) capacitor c=3.604E-17
    I_C303 (z_9 GND) capacitor c=2.757E-17
    I_C304 (n01_11 GND) capacitor c=3.061E-17
    I_C305 (XI0_I0_An_7 GND) capacitor c=4.246E-17
    I_C306 (XI8_Bn_3 GND) capacitor c=5.038E-17
    I_C307 (a_6 GND) capacitor c=9.487E-17
    I_C308 (n23_17 GND) capacitor c=3.881E-17
    I_C309 (XI0_I1_An_7 GND) capacitor c=4.546E-17
    I_C310 (n23_3 GND) capacitor c=2.660E-17
    I_C311 (I0_t05_5 GND) capacitor c=1.756E-19
    I_C312 (b_8 GND) capacitor c=8.609E-17
    I_C313 (n45_13 GND) capacitor c=4.158E-17
    I_C314 (XI0_I0_Bn_3 GND) capacitor c=5.067E-17
    I_C315 (q6n_3 GND) capacitor c=6.984E-20
    I_C316 (XI0_I1_Bn_3 GND) capacitor c=4.325E-17
    I_C317 (I0_t05_14 GND) capacitor c=7.088E-17
    I_C318 (tap_14 GND) capacitor c=7.439E-17
    I_C319 (tap_8 GND) capacitor c=7.566E-17
    I_C320 (FB_5 GND) capacitor c=7.595E-17
    I_C321 (I0_t67_11 GND) capacitor c=1.042E-16
    I_C322 (Q0_16 GND) capacitor c=6.088E-17
    I_C323 (b_11 GND) capacitor c=1.139E-16
    I_C324 (Q1_2 GND) capacitor c=1.081E-16
    I_C325 (n01_13 GND) capacitor c=3.149E-17
    I_C326 (Q0_6 GND) capacitor c=7.484E-17
    I_C327 (a_4 GND) capacitor c=1.023E-16
    I_C328 (n01_2 GND) capacitor c=1.063E-16
    I_C329 (Q2_2 GND) capacitor c=6.630E-17
    I_C330 (Q3_3 GND) capacitor c=1.133E-16
    I_C331 (Q6_17 GND) capacitor c=7.710E-17
    I_C332 (n23_5 GND) capacitor c=9.827E-17
    I_C333 (b_6 GND) capacitor c=1.010E-16
    I_C334 (I0_t05_6 GND) capacitor c=7.036E-17
    I_C335 (n45_11 GND) capacitor c=1.225E-16
    I_C336 (q6n_9 GND) capacitor c=7.693E-17
    I_C337 (Q5_9 GND) capacitor c=1.056E-16
    I_C338 (n45_3 GND) capacitor c=1.025E-16
    I_C339 (I0_t67_4 GND) capacitor c=7.275E-17
    I_C340 (Q5_3 GND) capacitor c=1.032E-16
    I_C341 (q6n_2 GND) capacitor c=1.012E-16
    I_C342 (Q7_1 GND) capacitor c=9.643E-17
    I_C343 (I0_t67_6 GND) capacitor c=3.420E-17
    I_C344 (Q5_11 GND) capacitor c=2.629E-16
    I_C345 (Q6_19 GND) capacitor c=9.513E-17
    I_C346 (a_7 GND) capacitor c=7.251E-17
    I_C347 (z_14 GND) capacitor c=9.528E-17
    I_C348 (tap_10 GND) capacitor c=3.955E-17
    I_C349 (tap_16 GND) capacitor c=1.302E-16
    I_C350 (I0_t67_18 GND) capacitor c=2.926E-16
ends CFSR_FB_CMOS
