// XOR2_TG6 sau layout (Assura RCX), cmp, corner FF
simulator lang=spectre
include "/home/buet/cadence/gpdk090_v4.6/models/spectre/gpdk090.scs" section=FF
include "../../cells/INV_X1/INV_X1.scs"
include "XOR2_TG6_rcx.scs"
include "../../tb/tb_XOR2_TG6_cmp.scs"
