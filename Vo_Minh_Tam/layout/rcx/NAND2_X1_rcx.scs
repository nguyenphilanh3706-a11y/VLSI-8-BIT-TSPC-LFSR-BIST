// NAND2_X1 sau layout: Assura RCX
simulator lang=spectre
subckt NAND2_X1 A B Y VDD GND
    I_MN0 (Y_2 A_3 n1 GND) gpdk090_nmos1v w=0.24u l=0.1u ad=0.0816p as=0.0528p pd=1.16u ps=0.68u
    I_MN1 (n1 B_3 GND GND) gpdk090_nmos1v w=0.24u l=0.1u ad=0.0528p as=0.0816p pd=0.68u ps=1.16u
    I_MP0 (Y_3 A_2 VDD VDD) gpdk090_pmos1v w=0.24u l=0.1u ad=0.0816p as=0.0528p pd=1.16u ps=0.68u
    I_MP1 (Y_4 B_2 VDD VDD) gpdk090_pmos1v w=0.24u l=0.1u ad=0.0816p as=0.0528p pd=1.16u ps=0.68u
    I_Rj1 (A_2 A_1) resistor r=48.5435
    I_Rj2 (A_1 A_3) resistor r=48.5435
    I_Rj3 (B_2 B_1) resistor r=48.5435
    I_Rj4 (B_1 B_3) resistor r=48.5435
    I_Ri1 (Y Y_1) resistor r=2.933E-02
    I_Ri2 (Y_1 Y_2) resistor r=15.5440
    I_Ri3 (Y Y_3) resistor r=15.1520
    I_Ri4 (A A_1) resistor r=10.0080
    I_Ri5 (B B_1) resistor r=10.0080
    I_Ri6 (Y_4 Y_5) resistor r=16.5813
    I_Rh1 (Y_5 Y_1) resistor r=1.8320
    I_C1 (VDD GND) capacitor c=2.502E-16
    I_C2 (A GND) capacitor c=1.035E-16
    I_C3 (B GND) capacitor c=7.564E-17
    I_C4 (Y GND) capacitor c=9.293E-17
    I_C5 (A_2 GND) capacitor c=6.095E-17
    I_C6 (B_2 GND) capacitor c=6.098E-17
    I_C7 (A_3 GND) capacitor c=5.772E-17
    I_C8 (B_3 GND) capacitor c=5.707E-17
    I_C9 (A_1 GND) capacitor c=6.270E-17
    I_C10 (B_1 GND) capacitor c=6.010E-17
    I_C11 (Y_1 GND) capacitor c=4.550E-17
    I_C12 (Y_5 GND) capacitor c=8.871E-17
    I_C13 (Y_3 GND) capacitor c=2.487E-17
    I_C14 (Y_4 GND) capacitor c=3.056E-17
    I_C15 (Y_2 GND) capacitor c=7.159E-17
ends NAND2_X1
