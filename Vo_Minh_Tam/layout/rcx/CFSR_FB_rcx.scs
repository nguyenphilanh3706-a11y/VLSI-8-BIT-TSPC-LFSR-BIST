// CFSR_FB sau layout: Assura RCX
simulator lang=spectre
subckt CFSR_FB Q0 Q1 Q2 Q3 Q4 Q5 Q6 Q7 FB VDD GND
    I_MXI0_I0_MN2 (I0_t05_4 XI0_I0_An_5 Q5_19 GND) gpdk090_nmos1v w=0.12u l=0.1u ad=0.0468p as=0.1992p pd=0.68u ps=2.24u
    I_MXI0_I0_MN1 (XI0_I0_An Q5_17 I0_t05_4 GND) gpdk090_nmos1v w=0.24u l=0.1u ad=0.0468p as=0.0468p pd=0.68u ps=0.68u
    I_MXI0_I0_MN0 (GND Q0_10 XI0_I0_An GND) gpdk090_nmos1v w=0.12u l=0.1u ad=0.0696p as=0.0468p pd=1.16u ps=0.68u
    I_MXI0_I1_MN2 (I0_t67_4 XI0_I1_An_5 Q7_12 GND) gpdk090_nmos1v w=0.12u l=0.1u ad=0.0468p as=0.1992p pd=0.68u ps=2.24u
    I_MXI0_I1_MN1 (XI0_I1_An Q7_11 I0_t67_4 GND) gpdk090_nmos1v w=0.24u l=0.1u ad=0.0468p as=0.0468p pd=0.68u ps=0.68u
    I_MXI0_I1_MN0 (GND Q6_8 XI0_I1_An GND) gpdk090_nmos1v w=0.12u l=0.1u ad=0.0696p as=0.0468p pd=1.16u ps=0.68u
    I_MXI0_I2_MN1 (XI0_I2_Bn_3 I0_t67_12 GND GND) gpdk090_nmos1v w=0.12u l=0.1u ad=0.0696p as=0.0696p pd=1.16u ps=1.16u
    I_MXI0_I2_MN5 (XI0_I2_n2 XI0_I2_Bn_8 GND GND) gpdk090_nmos1v w=0.24u l=0.1u ad=0.0528p as=0.0816p pd=0.68u ps=1.16u
    I_MXI0_I2_MN4 (tap_9 XI0_I2_An_4 XI0_I2_n2 GND) gpdk090_nmos1v w=0.24u l=0.1u ad=0.0528p as=0.0528p pd=0.68u ps=0.68u
    I_MXI0_I2_MN2 (XI0_I2_n1 I0_t05_10 tap_9 GND) gpdk090_nmos1v w=0.24u l=0.1u ad=0.0528p as=0.0528p pd=0.68u ps=0.68u
    I_MXI0_I2_MN3 (GND I0_t67_17 XI0_I2_n1 GND) gpdk090_nmos1v w=0.24u l=0.1u ad=0.0816p as=0.0528p pd=1.16u ps=0.68u
    I_MXI0_I2_MN0 (XI0_I2_An_7 I0_t05_18 GND GND) gpdk090_nmos1v w=0.12u l=0.1u ad=0.0696p as=0.0696p pd=1.16u ps=1.16u
    I_MXI2_MN1 (XI2_Bn_3 z_13 GND GND) gpdk090_nmos1v w=0.12u l=0.1u ad=0.0696p as=0.0696p pd=1.16u ps=1.16u
    I_MXI2_MN5 (XI2_n2 XI2_Bn_7 GND GND) gpdk090_nmos1v w=0.24u l=0.1u ad=0.0528p as=0.0816p pd=0.68u ps=1.16u
    I_MXI2_MN4 (FB_8 XI2_An_3 XI2_n2 GND) gpdk090_nmos1v w=0.24u l=0.1u ad=0.0528p as=0.0528p pd=0.68u ps=0.68u
    I_MXI2_MN2 (XI2_n1 tap_3 FB_8 GND) gpdk090_nmos1v w=0.24u l=0.1u ad=0.0528p as=0.0528p pd=0.68u ps=0.68u
    I_MXI2_MN3 (GND z_18 XI2_n1 GND) gpdk090_nmos1v w=0.24u l=0.1u ad=0.0816p as=0.0528p pd=1.16u ps=0.68u
    I_MXI2_MN0 (XI2_An_7 tap_16 GND GND) gpdk090_nmos1v w=0.12u l=0.1u ad=0.0696p as=0.0696p pd=1.16u ps=1.16u
    I_MXI1_I0_MN2 (GND Q2_4 I1_n012_11 GND) gpdk090_nmos1v w=0.12u l=0.1u ad=0.0408p as=0.0696p pd=0.68u ps=1.16u
    I_MXI1_I0_MN1 (I1_n012_17 Q1_6 GND GND) gpdk090_nmos1v w=0.12u l=0.1u ad=0.0408p as=0.0408p pd=0.68u ps=0.68u
    I_MXI1_I0_MN0 (GND Q0_5 I1_n012_17 GND) gpdk090_nmos1v w=0.12u l=0.1u ad=0.0696p as=0.0408p pd=1.16u ps=0.68u
    I_MXI1_I1_MN2 (GND Q5_7 I1_n345_13 GND) gpdk090_nmos1v w=0.12u l=0.1u ad=0.0408p as=0.0696p pd=0.68u ps=1.16u
    I_MXI1_I1_MN1 (I1_n345 Q4_9 GND GND) gpdk090_nmos1v w=0.12u l=0.1u ad=0.0408p as=0.0408p pd=0.68u ps=0.68u
    I_MXI1_I1_MN0 (GND Q3_7 I1_n345 GND) gpdk090_nmos1v w=0.12u l=0.1u ad=0.0696p as=0.0408p pd=1.16u ps=0.68u
    I_MXI1_I2_MN0 (XI1_I2_n1 I1_n012_5 I1_a_10 GND) gpdk090_nmos1v w=0.24u l=0.1u ad=0.0528p as=0.0816p pd=0.68u ps=1.16u
    I_MXI1_I2_MN1 (GND I1_n345_14 XI1_I2_n1 GND) gpdk090_nmos1v w=0.24u l=0.1u ad=0.0816p as=0.0528p pd=1.16u ps=0.68u
    I_MXI1_I3_MN1 (GND Q6_9 z_3 GND) gpdk090_nmos1v w=0.12u l=0.1u ad=0.0408p as=0.0696p pd=0.68u ps=1.16u
    I_MXI1_I3_MN0 (z I1_a_15 GND GND) gpdk090_nmos1v w=0.12u l=0.1u ad=0.0696p as=0.0408p pd=1.16u ps=0.68u
    I_MXI0_I0_MP0 (VDD Q0_21 XI0_I0_An_6 VDD) gpdk090_pmos1v w=0.24u l=0.1u ad=0.0816p as=0.0816p pd=1.16u ps=1.16u
    I_MXI0_I0_MP1 (I0_t05 Q5_18 Q0_13 VDD) gpdk090_pmos1v w=0.48u l=0.1u ad=0.0936p as=0.1632p pd=0.92u ps=1.64u
    I_MXI0_I0_MP2 (Q5_12 Q0_11 I0_t05 VDD) gpdk090_pmos1v w=0.24u l=0.1u ad=0.0816p as=0.0936p pd=1.16u ps=0.92u
    I_MXI0_I1_MP0 (VDD Q6_21 XI0_I1_An_6 VDD) gpdk090_pmos1v w=0.24u l=0.1u ad=0.0816p as=0.0816p pd=1.16u ps=1.16u
    I_MXI0_I1_MP1 (I0_t67 Q7_10 Q6_13 VDD) gpdk090_pmos1v w=0.48u l=0.1u ad=0.0936p as=0.1632p pd=0.92u ps=1.64u
    I_MXI0_I1_MP2 (Q7_5 Q6_7 I0_t67 VDD) gpdk090_pmos1v w=0.24u l=0.1u ad=0.0816p as=0.0936p pd=1.16u ps=0.92u
    I_MXI0_I2_MP1 (VDD I0_t67_11 XI0_I2_Bn VDD) gpdk090_pmos1v w=0.24u l=0.1u ad=0.0816p as=0.0816p pd=1.16u ps=1.16u
    I_MXI0_I2_MP5 (tap_5 XI0_I2_Bn_7 XI0_I2_p1_2 VDD) gpdk090_pmos1v w=0.48u l=0.1u ad=0.1056p as=0.1632p pd=0.92u ps=1.64u
    I_MXI0_I2_MP4 (XI0_I2_p1_4 XI0_I2_An_3 tap_5 VDD) gpdk090_pmos1v w=0.48u l=0.1u ad=0.1056p as=0.1056p pd=0.92u ps=0.92u
    I_MXI0_I2_MP2 (VDD I0_t05_9 XI0_I2_p1_4 VDD) gpdk090_pmos1v w=0.48u l=0.1u ad=0.1056p as=0.1056p pd=0.92u ps=0.92u
    I_MXI0_I2_MP3 (XI0_I2_p1_6 I0_t67_16 VDD VDD) gpdk090_pmos1v w=0.48u l=0.1u ad=0.1632p as=0.1056p pd=1.64u ps=0.92u
    I_MXI0_I2_MP0 (VDD I0_t05_16 XI0_I2_An_5 VDD) gpdk090_pmos1v w=0.24u l=0.1u ad=0.0816p as=0.0816p pd=1.16u ps=1.16u
    I_MXI2_MP1 (VDD z_14 XI2_Bn VDD) gpdk090_pmos1v w=0.24u l=0.1u ad=0.0816p as=0.0816p pd=1.16u ps=1.16u
    I_MXI2_MP5 (FB_1 XI2_Bn_8 XI2_p1 VDD) gpdk090_pmos1v w=0.48u l=0.1u ad=0.1056p as=0.1632p pd=0.92u ps=1.64u
    I_MXI2_MP4 (XI2_p1_3 XI2_An_4 FB_1 VDD) gpdk090_pmos1v w=0.48u l=0.1u ad=0.1056p as=0.1056p pd=0.92u ps=0.92u
    I_MXI2_MP2 (VDD tap_4 XI2_p1_3 VDD) gpdk090_pmos1v w=0.48u l=0.1u ad=0.1056p as=0.1056p pd=0.92u ps=0.92u
    I_MXI2_MP3 (XI2_p1_5 z_19 VDD VDD) gpdk090_pmos1v w=0.48u l=0.1u ad=0.1632p as=0.1056p pd=1.64u ps=0.92u
    I_MXI2_MP0 (VDD tap_18 XI2_An_5 VDD) gpdk090_pmos1v w=0.24u l=0.1u ad=0.0816p as=0.0816p pd=1.16u ps=1.16u
    I_MXI1_I0_MP2 (XI1_I0_p1 Q2_6 I1_n012_14 VDD) gpdk090_pmos1v w=0.48u l=0.1u ad=0.1056p as=0.1632p pd=0.92u ps=1.64u
    I_MXI1_I0_MP1 (XI1_I0_p2 Q1_8 XI1_I0_p1 VDD) gpdk090_pmos1v w=0.48u l=0.1u ad=0.1056p as=0.1056p pd=0.92u ps=0.92u
    I_MXI1_I0_MP0 (VDD Q0_7 XI1_I0_p2 VDD) gpdk090_pmos1v w=0.48u l=0.1u ad=0.1632p as=0.1056p pd=1.64u ps=0.92u
    I_MXI1_I1_MP2 (XI1_I1_p1 Q5_5 I1_n345_10 VDD) gpdk090_pmos1v w=0.48u l=0.1u ad=0.1056p as=0.1632p pd=0.92u ps=1.64u
    I_MXI1_I1_MP1 (XI1_I1_p2 Q4_7 XI1_I1_p1 VDD) gpdk090_pmos1v w=0.48u l=0.1u ad=0.1056p as=0.1056p pd=0.92u ps=0.92u
    I_MXI1_I1_MP0 (VDD Q3_5 XI1_I1_p2 VDD) gpdk090_pmos1v w=0.48u l=0.1u ad=0.1632p as=0.1056p pd=1.64u ps=0.92u
    I_MXI1_I2_MP0 (VDD I1_n012_7 I1_a_13 VDD) gpdk090_pmos1v w=0.24u l=0.1u ad=0.0528p as=0.0816p pd=0.68u ps=1.16u
    I_MXI1_I2_MP1 (I1_a I1_n345_16 VDD VDD) gpdk090_pmos1v w=0.24u l=0.1u ad=0.0816p as=0.0528p pd=1.16u ps=0.68u
    I_MXI1_I3_MP1 (XI1_I3_p1 Q6_11 z_6 VDD) gpdk090_pmos1v w=0.48u l=0.1u ad=0.1056p as=0.1632p pd=0.92u ps=1.64u
    I_MXI1_I3_MP0 (VDD I1_a_17 XI1_I3_p1 VDD) gpdk090_pmos1v w=0.48u l=0.1u ad=0.1632p as=0.1056p pd=1.64u ps=0.92u
    I_Rj1 (Q3_5 Q3_6) resistor r=36.5435
    I_Rj2 (Q3_6 Q3_7) resistor r=54.5435
    I_Rj3 (Q3_1 Q3_6) resistor r=10.0000
    I_Rj4 (Q4_7 Q4_8) resistor r=36.5435
    I_Rj5 (Q4_8 Q4_9) resistor r=54.5435
    I_Rj6 (Q4_4 Q4_8) resistor r=10.0000
    I_Rj7 (I1_n345_14 I1_n345_15) resistor r=48.5435
    I_Rj8 (I1_n345_15 I1_n345_16) resistor r=48.5435
    I_Rj9 (I1_n345_8 I1_n345_15) resistor r=10.0000
    I_Rj10 (Q5_5 Q5_6) resistor r=36.5435
    I_Rj11 (Q5_6 Q5_7) resistor r=54.5435
    I_Rj12 (Q5_3 Q5_6) resistor r=10.0000
    I_Rj13 (I1_n012_5 I1_n012_6) resistor r=48.5435
    I_Rj14 (I1_n012_6 I1_n012_7) resistor r=48.5435
    I_Rj15 (I1_n012_3 I1_n012_6) resistor r=10.0000
    I_Rj16 (I1_a_15 I1_a_16) resistor r=54.5435
    I_Rj17 (I1_a_16 I1_a_17) resistor r=36.5435
    I_Rj18 (I1_a_7 I1_a_16) resistor r=10.0000
    I_Rj19 (Q6_7 Q6_3) resistor r=48.5435
    I_Rj20 (Q6_3 Q6_8) resistor r=54.5435
    I_Rj21 (Q6_9 Q6_10) resistor r=54.5435
    I_Rj22 (Q6_10 Q6_11) resistor r=36.5435
    I_Rj23 (Q6_5 Q6_10) resistor r=10.0000
    I_Rj24 (Q2_4 Q2_5) resistor r=54.5435
    I_Rj25 (Q2_5 Q2_6) resistor r=36.5435
    I_Rj26 (Q2_3 Q2_5) resistor r=10.0000
    I_Rj27 (Q7_10 Q7_8) resistor r=36.5435
    I_Rj28 (Q7_8 Q7_11) resistor r=48.5435
    I_Rj29 (Q1_6 Q1_7) resistor r=54.5435
    I_Rj30 (Q1_7 Q1_8) resistor r=36.5435
    I_Rj31 (Q1_2 Q1_7) resistor r=10.0000
    I_Rj32 (XI0_I1_An_5 XI0_I1_An_3) resistor r=54.5435
    I_Rj33 (z_13 z_11) resistor r=54.5435
    I_Rj34 (z_11 z_14) resistor r=48.5435
    I_Rj35 (Q0_5 Q0_6) resistor r=54.5435
    I_Rj36 (Q0_6 Q0_7) resistor r=36.5435
    I_Rj37 (Q0_2 Q0_6) resistor r=10.0000
    I_Rj38 (Q6_21 Q6_15) resistor r=58.5435
    I_Rj39 (XI2_Bn_7 XI2_Bn_5) resistor r=48.5435
    I_Rj40 (XI2_Bn_5 XI2_Bn_8) resistor r=36.5435
    I_Rj41 (Q0_10 Q0_8) resistor r=54.5435
    I_Rj42 (Q0_8 Q0_11) resistor r=48.5435
    I_Rj43 (I0_t67_11 I0_t67_7) resistor r=48.5435
    I_Rj44 (I0_t67_7 I0_t67_12) resistor r=54.5435
    I_Rj45 (XI2_An_3 XI2_An) resistor r=48.5435
    I_Rj46 (XI2_An XI2_An_4) resistor r=36.5435
    I_Rj47 (Q5_17 Q5_15) resistor r=48.5435
    I_Rj48 (Q5_15 Q5_18) resistor r=36.5435
    I_Rj49 (tap_3 tap) resistor r=48.5435
    I_Rj50 (tap tap_4) resistor r=36.5435
    I_Rj51 (XI0_I0_An_5 XI0_I0_An_3) resistor r=54.5435
    I_Rj52 (XI0_I2_Bn_7 XI0_I2_Bn_5) resistor r=36.5435
    I_Rj53 (XI0_I2_Bn_5 XI0_I2_Bn_8) resistor r=48.5435
    I_Rj54 (z_18 z_16) resistor r=48.5435
    I_Rj55 (z_16 z_19) resistor r=36.5435
    I_Rj56 (Q0_21 Q0_17) resistor r=58.5435
    I_Rj57 (XI0_I2_An_3 XI0_I2_An) resistor r=36.5435
    I_Rj58 (XI0_I2_An XI0_I2_An_4) resistor r=48.5435
    I_Rj59 (I0_t05_9 I0_t05_7) resistor r=36.5435
    I_Rj60 (I0_t05_7 I0_t05_10) resistor r=48.5435
    I_Rj61 (tap_16 tap_17) resistor r=54.5435
    I_Rj62 (tap_17 tap_18) resistor r=48.5435
    I_Rj63 (tap_13 tap_17) resistor r=10.0000
    I_Rj64 (I0_t67_16 I0_t67_13) resistor r=36.5435
    I_Rj65 (I0_t67_13 I0_t67_17) resistor r=48.5435
    I_Rj66 (I0_t05_16 I0_t05_17) resistor r=48.5435
    I_Rj67 (I0_t05_17 I0_t05_18) resistor r=54.5435
    I_Rj68 (I0_t05_11 I0_t05_17) resistor r=10.0000
    I_Ri2 (Q3_1 Q3_3) resistor r=9.167E-03
    I_Ri3 (I1_n345 I1_n345_2) resistor r=16.4800
    I_Ri5 (Q4_4 Q4_6) resistor r=8.333E-03
    I_Ri6 (I1_a I1_a_2) resistor r=16.5813
    I_Ri8 (I1_n345_8 I1_n345_7) resistor r=1.083E-02
    I_Ri10 (Q5_3 Q5_2) resistor r=1.083E-02
    I_Ri11 (I1_n345_10 I1_n345_11) resistor r=15.5787
    I_Ri12 (I1_n345_11 I1_n345_12) resistor r=6.667E-02
    I_Ri13 (I1_n345_12 I1_n345_13) resistor r=15.0800
    I_Ri14 (z z_2) resistor r=16.4800
    I_Ri16 (I1_n012_3 I1_n012_2) resistor r=1.083E-02
    I_Ri18 (I1_a_7 I1_a_5) resistor r=1.083E-02
    I_Ri19 (I1_a_10 I1_a_11) resistor r=15.5440
    I_Ri20 (I1_a_11 I1_a_12) resistor r=2.933E-02
    I_Ri21 (I1_a_12 I1_a_13) resistor r=15.1520
    I_Ri22 (Q7_5 Q7_6) resistor r=15.3600
    I_Ri23 (Q7_6 Q7_7) resistor r=1.5307
    I_Ri24 (Q6_3 Q6_4) resistor r=11.7360
    I_Ri26 (Q6_5 Q6_1) resistor r=1.250E-02
    I_Ri27 (I1_n012_11 I1_n012_12) resistor r=15.0800
    I_Ri28 (I1_n012_12 I1_n012_13) resistor r=6.667E-02
    I_Ri29 (I1_n012_13 I1_n012_15) resistor r=0.5787
    I_Ri30 (I1_n012_15 I1_n012_16) resistor r=1.200E-02
    I_Ri31 (I1_n012_14 I1_n012_15) resistor r=15.0000
    I_Ri32 (I0_t67 I0_t67_2) resistor r=15.3013
    I_Ri33 (I0_t67_2 I0_t67_3) resistor r=1.4347
    I_Ri34 (XI0_I1_An XI0_I1_An_2) resistor r=16.4800
    I_Ri35 (z_3 z_4) resistor r=15.0800
    I_Ri36 (z_4 z_5) resistor r=6.667E-02
    I_Ri37 (z_5 z_6) resistor r=15.5787
    I_Ri38 (Q7_8 Q7_9) resistor r=11.5280
    I_Ri39 (Q2_2 Q2_3) resistor r=2.667E-03
    I_Ri40 (Q2_2 Q2_1) resistor r=4.444E-02
    I_Ri41 (Q6_12 Q6_13) resistor r=16.4267
    I_Ri42 (I0_t67_4 I0_t67_5) resistor r=16.7893
    I_Ri43 (XI2_Bn XI2_Bn_2) resistor r=16.8907
    I_Ri44 (XI0_I1_An_3 XI0_I1_An_4) resistor r=11.6827
    I_Ri45 (z_9 z_10) resistor r=3.467E-02
    I_Ri46 (z_10 z_11) resistor r=10.0267
    I_Ri47 (Q1_1 Q1_2) resistor r=1.4008
    I_Ri49 (I1_n012_17 I1_n012_18) resistor r=16.4800
    I_Ri50 (Q7_12 Q7_13) resistor r=16.6347
    I_Ri51 (XI2_Bn_3 XI2_Bn_4) resistor r=16.6347
    I_Ri52 (Q6_15 Q6_16) resistor r=6.133E-02
    I_Ri53 (Q6_16 Q6_17) resistor r=1.6747
    I_Ri54 (Q0_1 Q0_2) resistor r=2.667E-03
    I_Ri55 (Q0_1 Q0_3) resistor r=1.4462
    I_Ri56 (XI0_I1_An_6 XI0_I1_An_7) resistor r=17.0453
    I_Ri57 (XI2_p1 XI2_p1_2) resistor r=16.4267
    I_Ri58 (XI2_Bn_5 XI2_Bn_6) resistor r=11.5280
    I_Ri59 (Q5_12 Q5_10) resistor r=15.1121
    I_Ri60 (Q5_10 Q5_13) resistor r=0.2108
    I_Ri61 (Q5_13 Q5_14) resistor r=1.5307
    I_Ri62 (XI0_I2_Bn XI0_I2_Bn_2) resistor r=16.8907
    I_Ri63 (FB_1 FB_2) resistor r=17.0453
    I_Ri64 (Q0_8 Q0_9) resistor r=11.7360
    I_Ri65 (I0_t67_7 I0_t67_8) resistor r=10.0267
    I_Ri66 (I0_t67_8 I0_t67_9) resistor r=3.467E-02
    I_Ri67 (XI2_An XI2_An_2) resistor r=11.5280
    I_Ri68 (XI0_I0_An XI0_I0_An_2) resistor r=16.4800
    I_Ri69 (I0_t05 I0_t05_2) resistor r=15.3013
    I_Ri70 (I0_t05_2 I0_t05_3) resistor r=1.4347
    I_Ri71 (XI0_I2_Bn_3 XI0_I2_Bn_4) resistor r=16.6347
    I_Ri72 (FB_4 FB_7) resistor r=3.467E-02
    I_Ri73 (FB_7 FB_8) resistor r=15.0453
    I_Ri74 (XI2_p1_3 XI2_p1_4) resistor r=16.4267
    I_Ri75 (Q5_15 Q5_16) resistor r=11.5280
    I_Ri76 (tap tap_2) resistor r=11.5813
    I_Ri77 (I0_t05_4 I0_t05_5) resistor r=16.7893
    I_Ri78 (Q0_13 Q0_14) resistor r=16.4267
    I_Ri79 (XI0_I2_p1 XI0_I2_p1_2) resistor r=16.4267
    I_Ri80 (XI0_I0_An_3 XI0_I0_An_4) resistor r=11.6827
    I_Ri81 (XI0_I2_Bn_5 XI0_I2_Bn_6) resistor r=11.5280
    I_Ri82 (z_15 z_16) resistor r=11.4267
    I_Ri83 (Q5_19 Q5_20) resistor r=16.6347
    I_Ri84 (tap_5 tap_6) resistor r=17.0453
    I_Ri85 (XI2_p1_5 XI2_p1_6) resistor r=16.4267
    I_Ri87 (Q0_17 Q0_19) resistor r=1.405E-02
    I_Ri88 (Q0_19 Q0_16) resistor r=0.2130
    I_Ri89 (XI0_I2_An XI0_I2_An_2) resistor r=11.5280
    I_Ri90 (XI0_I0_An_6 XI0_I0_An_7) resistor r=17.0453
    I_Ri91 (XI0_I2_p1_3 XI0_I2_p1_4) resistor r=16.4267
    I_Ri92 (tap_9 tap_10) resistor r=15.0453
    I_Ri93 (tap_10 tap_11) resistor r=1.4347
    I_Ri94 (XI2_An_5 XI2_An_6) resistor r=16.8907
    I_Ri95 (I0_t05_7 I0_t05_8) resistor r=11.5813
    I_Ri96 (tap_13 tap_14) resistor r=6.133E-02
    I_Ri97 (tap_14 tap_15) resistor r=1.5200
    I_Ri98 (XI2_An_7 XI2_An_8) resistor r=16.6347
    I_Ri99 (I0_t67_13 I0_t67_14) resistor r=11.4267
    I_Ri100 (XI0_I2_p1_5 XI0_I2_p1_6) resistor r=15.0267
    I_Ri101 (XI0_I2_An_5 XI0_I2_An_6) resistor r=16.8907
    I_Ri102 (I0_t05_11 I0_t05_12) resistor r=6.133E-02
    I_Ri103 (I0_t05_12 I0_t05_13) resistor r=1.5200
    I_Ri104 (XI0_I2_An_7 XI0_I2_An_8) resistor r=16.6347
    I_Rh1 (Q3_3 Q3_4) resistor r=2.9019
    I_Rh2 (Q4_6 Q4_1) resistor r=1.6415
    I_Rh3 (Q5_1 Q5_2) resistor r=3.0415
    I_Rh4 (I1_n345_7 I1_n345_3) resistor r=1.5405
    I_Rh5 (I1_n345_12 I1_n345_6) resistor r=1.6721
    I_Rh6 (I1_n345_6 I1_n345_2) resistor r=0.1321
    I_Rh7 (I1_n012 I1_n012_2) resistor r=3.0415
    I_Rh8 (I1_a_5 I1_a_4) resistor r=1.5234
    I_Rh9 (Q7 Q7_1) resistor r=3.0754
    I_Rh10 (I1_a_2 I1_a_14) resistor r=0.4320
    I_Rh11 (I1_a_14 I1_a_9) resistor r=0.8903
    I_Rh12 (I1_a_11 I1_a_14) resistor r=1.4000
    I_Rh13 (Q6_1 Q6_2) resistor r=3.0415
    I_Rh14 (I1_n012_16 I1_n012_9) resistor r=1.5019
    I_Rh15 (z_2 z_7) resistor r=0.4320
    I_Rh16 (z_7 z_8) resistor r=1.7913
    I_Rh17 (z_4 z_7) resistor r=1.4000
    I_Rh18 (Q2 Q2_1) resistor r=3.5186
    I_Rh19 (Q6 Q6_14) resistor r=2.9511
    I_Rh20 (I0_t67_3 I0_t67_6) resistor r=0.1909
    I_Rh21 (I0_t67_6 I0_t67_5) resistor r=3.000E-03
    I_Rh22 (Q1 Q1_4) resistor r=2.6897
    I_Rh23 (Q1_5 Q1_1) resistor r=1.5019
    I_Rh24 (I1_n012_18 I1_n012_12) resistor r=1.8320
    I_Rh25 (Q7_13 Q7_9) resistor r=0.3240
    I_Rh26 (Q7_9 Q7_7) resistor r=0.3140
    I_Rh27 (Q7_7 Q7_2) resistor r=3.407E-02
    I_Rh28 (Q6_17 Q6_18) resistor r=8.407E-02
    I_Rh29 (Q6_18 Q6_12) resistor r=0.2121
    I_Rh30 (Q6_12 Q6_4) resistor r=0.3240
    I_Rh31 (XI0_I1_An_7 XI0_I1_An_4) resistor r=0.3240
    I_Rh32 (XI0_I1_An_4 XI0_I1_An_2) resistor r=0.3240
    I_Rh33 (Q0_4 Q0_3) resistor r=1.8560
    I_Rh34 (XI2_Bn_6 XI2_Bn_4) resistor r=0.3240
    I_Rh35 (XI2_Bn_4 XI2_Bn_2) resistor r=0.2160
    I_Rh36 (Q5_10 Q5_11) resistor r=2.9491
    I_Rh37 (FB FB_3) resistor r=2.8268
    I_Rh38 (FB_4 FB_5) resistor r=1.4559
    I_Rh39 (FB_5 FB_2) resistor r=0.1559
    I_Rh40 (FB_5 FB_6) resistor r=1.5833
    I_Rh41 (Q0 Q0_12) resistor r=2.6897
    I_Rh42 (I0_t05_6 I0_t05_5) resistor r=2.377E-02
    I_Rh43 (I0_t05_6 I0_t05_3) resistor r=0.1673
    I_Rh44 (XI0_I2_Bn_6 XI0_I2_Bn_4) resistor r=0.3240
    I_Rh45 (XI0_I2_Bn_4 XI0_I2_Bn_2) resistor r=0.2160
    I_Rh46 (z_15 z_17) resistor r=1.0800
    I_Rh47 (z_17 z_12) resistor r=0.1470
    I_Rh48 (z_10 z_17) resistor r=1.4000
    I_Rh49 (Q5_20 Q5_16) resistor r=0.3240
    I_Rh50 (Q5_16 Q5_14) resistor r=0.3240
    I_Rh51 (XI2_p1_6 XI2_p1_4) resistor r=0.4320
    I_Rh52 (XI2_p1_4 XI2_p1_2) resistor r=0.4320
    I_Rh53 (Q0_16 Q0_14) resistor r=1.7240
    I_Rh54 (Q0_14 Q0_9) resistor r=0.3240
    I_Rh55 (Q0_20 Q0_19) resistor r=2.9105
    I_Rh56 (tap_11 tap_12) resistor r=0.1239
    I_Rh57 (tap_12 tap_6) resistor r=8.792E-02
    I_Rh58 (tap_12 tap_7) resistor r=0.5605
    I_Rh59 (XI0_I0_An_7 XI0_I0_An_4) resistor r=0.3240
    I_Rh60 (XI0_I0_An_4 XI0_I0_An_2) resistor r=0.3240
    I_Rh61 (tap_15 tap_8) resistor r=0.2210
    I_Rh62 (tap_8 tap_2) resistor r=0.4010
    I_Rh63 (XI2_An_8 XI2_An_6) resistor r=0.2160
    I_Rh64 (XI2_An_6 XI2_An_2) resistor r=0.7560
    I_Rh65 (I0_t67_14 I0_t67_10) resistor r=1.0287
    I_Rh66 (I0_t67_10 I0_t67_15) resistor r=2.679E-02
    I_Rh67 (I0_t67_8 I0_t67_15) resistor r=1.4000
    I_Rh68 (XI0_I2_p1_5 XI0_I2_p1_3) resistor r=1.8320
    I_Rh69 (XI0_I2_p1_3 XI0_I2_p1) resistor r=0.4320
    I_Rh70 (I0_t05_13 I0_t05_14) resistor r=0.1839
    I_Rh71 (I0_t05_14 I0_t05_8) resistor r=0.4599
    I_Rh72 (I0_t05_14 I0_t05_15) resistor r=2.2733
    I_Rh73 (XI0_I2_An_8 XI0_I2_An_6) resistor r=0.2160
    I_Rh74 (XI0_I2_An_6 XI0_I2_An_2) resistor r=0.7560
    I_Rg1 (Q3 Q3_4) resistor r=2.2966
    I_Rg2 (Q4_1 Q4_2) resistor r=5.2786
    I_Rg3 (I1_n345_3 I1_n345_4) resistor r=2.9019
    I_Rg4 (I1_n345_5 I1_n345_6) resistor r=2.9019
    I_Rg5 (I1_a_3 I1_a_4) resistor r=2.9019
    I_Rg6 (Q7_2 Q7_3) resistor r=2.9019
    I_Rg7 (Q7_4 Q7_1) resistor r=1.5019
    I_Rg8 (I1_a_9 I1_a_6) resistor r=1.6415
    I_Rg9 (I1_n012_8 I1_n012_9) resistor r=2.9019
    I_Rg10 (I1_n012_10 I1_n012) resistor r=1.6201
    I_Rg11 (Q5_8 Q5_1) resistor r=2.2244
    I_Rg12 (z_12 z_8) resistor r=1.7658
    I_Rg13 (Q1_5 Q1_4) resistor r=0.4218
    I_Rg14 (Q6_18 Q6_19) resistor r=2.9019
    I_Rg15 (Q6_20 Q6_14) resistor r=1.6415
    I_Rg16 (Q6_14 Q6_2) resistor r=0.3658
    I_Rg17 (Q5_11 Q5_9) resistor r=1.8901
    I_Rg18 (I0_t67_10 I0_t67_6) resistor r=3.6629
    I_Rg19 (FB_9 FB_6) resistor r=1.6415
    I_Rg20 (FB_10 FB_3) resistor r=1.7658
    I_Rg21 (Q0_15 Q0_12) resistor r=1.7658
    I_Rg22 (Q0_12 Q0_4) resistor r=0.4901
    I_Rg23 (tap_7 tap_8) resistor r=3.2127
    I_Rg24 (Q0_20 Q0_22) resistor r=1.6415
    I_Rg25 (I0_t05_15 I0_t05_6) resistor r=2.6167
    I_Rf1 (Q4_2 Q4_3) resistor r=1.6415
    I_Rf2 (I1_n345_4 I1_n345_5) resistor r=1.2358
    I_Rf3 (I1_a_6 I1_a_3) resistor r=2.5115
    I_Rf4 (Q7_3 Q7_4) resistor r=0.9872
    I_Rf5 (I1_n012_10 I1_n012_8) resistor r=0.4901
    I_Rf6 (Q5 Q5_9) resistor r=1.9111
    I_Rf7 (Q5_9 Q5_8) resistor r=0.7386
    I_Rf8 (Q6_19 Q6_20) resistor r=1.6086
    I_Rf9 (FB_9 FB_10) resistor r=0.8629
    I_Rf10 (Q0_15 Q0_22) resistor r=0.4901
    I_Re1 (Q4 Q4_3) resistor r=5.946E-02
    I_C1 (VDD GND) capacitor c=8.600E-15
    I_C2 (FB GND) capacitor c=1.508E-16
    I_C3 (Q0 GND) capacitor c=1.414E-16
    I_C4 (Q1 GND) capacitor c=1.575E-16
    I_C5 (Q2 GND) capacitor c=2.661E-16
    I_C6 (Q3 GND) capacitor c=2.724E-16
    I_C7 (Q4 GND) capacitor c=2.976E-17
    I_C8 (Q5 GND) capacitor c=1.799E-16
    I_C9 (Q6 GND) capacitor c=1.696E-16
    I_C10 (Q7 GND) capacitor c=1.830E-16
    I_C11 (I1_a GND) capacitor c=2.936E-17
    I_C12 (z GND) capacitor c=3.435E-17
    I_C13 (I1_n012 GND) capacitor c=6.895E-17
    I_C14 (I1_n345 GND) capacitor c=3.847E-17
    I_C15 (tap GND) capacitor c=9.523E-17
    I_C16 (I0_t05 GND) capacitor c=8.486E-17
    I_C17 (I0_t67 GND) capacitor c=7.996E-17
    I_C18 (XI0_I0_An GND) capacitor c=4.369E-17
    I_C19 (XI0_I1_An GND) capacitor c=4.160E-17
    I_C20 (XI0_I2_p1 GND) capacitor c=1.358E-16
    I_C21 (XI0_I2_n2 GND) capacitor c=9.282E-18
    I_C22 (XI0_I2_An GND) capacitor c=1.068E-16
    I_C23 (XI0_I2_Bn GND) capacitor c=8.586E-17
    I_C24 (XI2_n1 GND) capacitor c=3.820E-19
    I_C25 (XI2_n2 GND) capacitor c=9.002E-18
    I_C26 (XI2_An GND) capacitor c=1.055E-16
    I_C27 (XI2_Bn GND) capacitor c=9.900E-17
    I_C28 (XI1_I0_p2 GND) capacitor c=1.938E-18
    I_C29 (XI1_I0_p1 GND) capacitor c=1.106E-18
    I_C30 (XI1_I1_p2 GND) capacitor c=2.292E-17
    I_C31 (XI1_I1_p1 GND) capacitor c=4.633E-18
    I_C32 (XI1_I2_n1 GND) capacitor c=1.034E-17
    I_C33 (XI1_I3_p1 GND) capacitor c=2.439E-17
    I_C34 (I0_t05_16 GND) capacitor c=5.922E-17
    I_C35 (I0_t67_16 GND) capacitor c=6.071E-17
    I_C36 (I0_t05_9 GND) capacitor c=5.729E-17
    I_C37 (tap_18 GND) capacitor c=5.463E-17
    I_C38 (Q0_21 GND) capacitor c=4.517E-17
    I_C39 (XI0_I2_An_3 GND) capacitor c=6.541E-17
    I_C40 (XI0_I2_Bn_7 GND) capacitor c=6.571E-17
    I_C41 (z_19 GND) capacitor c=6.772E-17
    I_C42 (Q5_18 GND) capacitor c=6.614E-17
    I_C43 (tap_4 GND) capacitor c=5.700E-17
    I_C44 (Q0_11 GND) capacitor c=4.324E-17
    I_C45 (I0_t67_11 GND) capacitor c=6.032E-17
    I_C46 (XI2_An_4 GND) capacitor c=6.250E-17
    I_C47 (XI2_Bn_8 GND) capacitor c=6.354E-17
    I_C48 (Q0_7 GND) capacitor c=5.653E-17
    I_C49 (Q6_21 GND) capacitor c=6.596E-17
    I_C50 (Q1_8 GND) capacitor c=5.765E-17
    I_C51 (z_14 GND) capacitor c=5.224E-17
    I_C52 (Q2_6 GND) capacitor c=4.949E-17
    I_C53 (Q7_10 GND) capacitor c=6.247E-17
    I_C54 (Q6_7 GND) capacitor c=4.909E-17
    I_C55 (Q6_11 GND) capacitor c=4.872E-17
    I_C56 (I1_n012_7 GND) capacitor c=5.324E-17
    I_C57 (I1_a_17 GND) capacitor c=5.020E-17
    I_C58 (I1_n345_16 GND) capacitor c=5.257E-17
    I_C59 (Q5_5 GND) capacitor c=5.181E-17
    I_C60 (Q4_7 GND) capacitor c=5.032E-17
    I_C61 (Q3_5 GND) capacitor c=5.238E-17
    I_C62 (I0_t05_18 GND) capacitor c=5.799E-17
    I_C63 (I0_t67_17 GND) capacitor c=5.904E-17
    I_C64 (I0_t05_10 GND) capacitor c=5.861E-17
    I_C65 (tap_16 GND) capacitor c=5.609E-17
    I_C66 (XI0_I2_An_4 GND) capacitor c=5.263E-17
    I_C67 (XI0_I0_An_5 GND) capacitor c=3.869E-17
    I_C68 (XI0_I2_Bn_8 GND) capacitor c=5.042E-17
    I_C69 (z_18 GND) capacitor c=5.541E-17
    I_C70 (Q5_17 GND) capacitor c=6.055E-17
    I_C71 (tap_3 GND) capacitor c=5.302E-17
    I_C72 (Q0_10 GND) capacitor c=4.762E-17
    I_C73 (I0_t67_12 GND) capacitor c=5.838E-17
    I_C74 (XI2_An_3 GND) capacitor c=5.111E-17
    I_C75 (XI2_Bn_7 GND) capacitor c=5.873E-17
    I_C76 (Q0_5 GND) capacitor c=4.766E-17
    I_C77 (Q1_6 GND) capacitor c=5.488E-17
    I_C78 (XI0_I1_An_5 GND) capacitor c=3.573E-17
    I_C79 (z_13 GND) capacitor c=4.944E-17
    I_C80 (Q2_4 GND) capacitor c=5.174E-17
    I_C81 (Q7_11 GND) capacitor c=5.580E-17
    I_C82 (Q6_8 GND) capacitor c=5.721E-17
    I_C83 (Q6_9 GND) capacitor c=5.329E-17
    I_C84 (I1_n012_5 GND) capacitor c=4.592E-17
    I_C85 (I1_a_15 GND) capacitor c=5.049E-17
    I_C86 (I1_n345_14 GND) capacitor c=5.401E-17
    I_C87 (Q5_7 GND) capacitor c=5.688E-17
    I_C88 (Q4_9 GND) capacitor c=5.906E-17
    I_C89 (Q3_7 GND) capacitor c=5.913E-17
    I_C90 (I0_t05_15 GND) capacitor c=1.510E-16
    I_C91 (Q0_20 GND) capacitor c=1.055E-16
    I_C92 (tap_7 GND) capacitor c=1.370E-16
    I_C93 (tap_8 GND) capacitor c=1.891E-16
    I_C94 (I0_t05_6 GND) capacitor c=2.903E-16
    I_C95 (Q0_12 GND) capacitor c=2.177E-16
    I_C96 (I0_t67_10 GND) capacitor c=5.898E-17
    I_C97 (FB_6 GND) capacitor c=6.216E-17
    I_C98 (FB_3 GND) capacitor c=1.998E-16
    I_C99 (Q0_4 GND) capacitor c=1.245E-16
    I_C100 (Q5_11 GND) capacitor c=8.450E-17
    I_C101 (Q1_5 GND) capacitor c=1.238E-16
    I_C102 (Q6_18 GND) capacitor c=5.851E-17
    I_C103 (Q1_4 GND) capacitor c=2.320E-16
    I_C104 (z_12 GND) capacitor c=1.444E-16
    I_C105 (I0_t67_6 GND) capacitor c=2.169E-16
    I_C106 (Q6_14 GND) capacitor c=2.725E-16
    I_C107 (z_8 GND) capacitor c=1.682E-16
    I_C108 (I1_n012_9 GND) capacitor c=8.347E-17
    I_C109 (Q6_2 GND) capacitor c=1.573E-16
    I_C110 (I1_a_9 GND) capacitor c=1.925E-16
    I_C111 (Q7_2 GND) capacitor c=8.244E-17
    I_C112 (Q7_1 GND) capacitor c=2.701E-16
    I_C113 (I1_a_4 GND) capacitor c=6.716E-17
    I_C114 (Q5_1 GND) capacitor c=1.878E-16
    I_C115 (I1_n345_3 GND) capacitor c=5.423E-17
    I_C116 (I1_n345_6 GND) capacitor c=7.563E-17
    I_C117 (Q4_1 GND) capacitor c=2.801E-16
    I_C118 (Q3_4 GND) capacitor c=2.242E-16
    I_C119 (I0_t05_11 GND) capacitor c=6.507E-17
    I_C120 (I0_t67_13 GND) capacitor c=5.369E-17
    I_C121 (I0_t05_7 GND) capacitor c=9.757E-17
    I_C122 (tap_13 GND) capacitor c=6.199E-17
    I_C123 (Q0_17 GND) capacitor c=1.518E-16
    I_C124 (XI0_I0_An_3 GND) capacitor c=1.436E-16
    I_C125 (XI0_I2_Bn_5 GND) capacitor c=1.020E-16
    I_C126 (z_16 GND) capacitor c=5.380E-17
    I_C127 (Q5_15 GND) capacitor c=1.252E-16
    I_C128 (Q0_8 GND) capacitor c=1.740E-16
    I_C129 (I0_t67_7 GND) capacitor c=6.780E-17
    I_C130 (XI2_Bn_5 GND) capacitor c=1.008E-16
    I_C131 (Q0_2 GND) capacitor c=5.238E-17
    I_C132 (Q6_15 GND) capacitor c=5.526E-17
    I_C133 (Q1_2 GND) capacitor c=1.217E-16
    I_C134 (XI0_I1_An_3 GND) capacitor c=1.378E-16
    I_C135 (z_11 GND) capacitor c=6.264E-17
    I_C136 (Q2_3 GND) capacitor c=6.008E-17
    I_C137 (Q7_8 GND) capacitor c=1.268E-16
    I_C138 (Q6_3 GND) capacitor c=1.822E-16
    I_C139 (Q6_5 GND) capacitor c=1.741E-16
    I_C140 (I1_n012_3 GND) capacitor c=6.158E-17
    I_C141 (I1_a_7 GND) capacitor c=5.009E-17
    I_C142 (I1_n345_8 GND) capacitor c=4.990E-17
    I_C143 (Q5_3 GND) capacitor c=6.407E-17
    I_C144 (Q4_4 GND) capacitor c=6.508E-17
    I_C145 (Q3_1 GND) capacitor c=1.098E-16
    I_C146 (Q4_3 GND) capacitor c=6.514E-17
    I_C147 (Q0_15 GND) capacitor c=7.937E-17
    I_C148 (Q0_22 GND) capacitor c=9.877E-17
    I_C149 (FB_9 GND) capacitor c=9.546E-17
    I_C150 (FB_10 GND) capacitor c=1.037E-16
    I_C151 (Q6_19 GND) capacitor c=1.482E-16
    I_C152 (Q6_20 GND) capacitor c=1.564E-16
    I_C153 (Q5_9 GND) capacitor c=2.241E-16
    I_C154 (Q5_8 GND) capacitor c=1.404E-16
    I_C155 (I1_n012_10 GND) capacitor c=7.534E-17
    I_C156 (I1_n012_8 GND) capacitor c=6.517E-17
    I_C157 (Q7_3 GND) capacitor c=1.244E-16
    I_C158 (Q7_4 GND) capacitor c=1.116E-16
    I_C159 (I1_a_6 GND) capacitor c=1.883E-16
    I_C160 (I1_a_3 GND) capacitor c=1.397E-16
    I_C161 (I1_n345_4 GND) capacitor c=9.371E-17
    I_C162 (I1_n345_5 GND) capacitor c=1.128E-16
    I_C163 (Q4_2 GND) capacitor c=2.972E-16
    I_C164 (XI0_I2_An_8 GND) capacitor c=7.653E-17
    I_C165 (I0_t05_13 GND) capacitor c=8.124E-17
    I_C166 (XI0_I2_An_6 GND) capacitor c=2.061E-16
    I_C167 (XI0_I2_p1_5 GND) capacitor c=1.827E-16
    I_C168 (I0_t67_14 GND) capacitor c=3.673E-16
    I_C169 (XI2_An_8 GND) capacitor c=7.795E-17
    I_C170 (I0_t05_8 GND) capacitor c=2.122E-16
    I_C171 (tap_15 GND) capacitor c=9.095E-17
    I_C172 (XI0_I0_An_7 GND) capacitor c=1.641E-16
    I_C173 (XI0_I2_p1_3 GND) capacitor c=2.018E-16
    I_C174 (tap_11 GND) capacitor c=4.848E-17
    I_C175 (XI2_An_6 GND) capacitor c=2.355E-16
    I_C176 (Q0_16 GND) capacitor c=1.197E-16
    I_C177 (XI0_I2_An_2 GND) capacitor c=2.689E-16
    I_C178 (Q0_19 GND) capacitor c=3.193E-17
    I_C179 (Q5_20 GND) capacitor c=1.823E-16
    I_C180 (tap_6 GND) capacitor c=1.790E-16
    I_C181 (XI2_p1_6 GND) capacitor c=1.747E-16
    I_C182 (XI0_I0_An_4 GND) capacitor c=2.167E-16
    I_C183 (XI0_I2_Bn_6 GND) capacitor c=1.322E-16
    I_C184 (z_15 GND) capacitor c=4.005E-16
    I_C185 (I0_t05_5 GND) capacitor c=1.215E-16
    I_C186 (Q0_14 GND) capacitor c=1.372E-16
    I_C187 (Q5_16 GND) capacitor c=2.431E-16
    I_C188 (tap_2 GND) capacitor c=2.097E-16
    I_C189 (XI0_I0_An_2 GND) capacitor c=1.586E-16
    I_C190 (I0_t05_3 GND) capacitor c=7.413E-17
    I_C191 (XI0_I2_Bn_4 GND) capacitor c=1.386E-16
    I_C192 (XI2_p1_4 GND) capacitor c=2.381E-16
    I_C193 (Q0_9 GND) capacitor c=1.477E-16
    I_C194 (I0_t67_8 GND) capacitor c=2.517E-16
    I_C195 (XI2_An_2 GND) capacitor c=2.915E-16
    I_C196 (Q5_14 GND) capacitor c=8.637E-17
    I_C197 (XI0_I2_Bn_2 GND) capacitor c=1.693E-16
    I_C198 (FB_2 GND) capacitor c=1.985E-16
    I_C199 (Q5_10 GND) capacitor c=7.295E-17
    I_C200 (XI2_Bn_6 GND) capacitor c=1.318E-16
    I_C201 (XI0_I1_An_7 GND) capacitor c=1.645E-16
    I_C202 (XI2_p1_2 GND) capacitor c=1.420E-16
    I_C203 (Q0_3 GND) capacitor c=1.008E-16
    I_C204 (Q6_17 GND) capacitor c=9.541E-17
    I_C205 (I1_n012_18 GND) capacitor c=1.398E-16
    I_C206 (Q7_13 GND) capacitor c=1.803E-16
    I_C207 (XI2_Bn_4 GND) capacitor c=1.351E-16
    I_C208 (Q1_1 GND) capacitor c=4.650E-17
    I_C209 (XI0_I1_An_4 GND) capacitor c=2.069E-16
    I_C210 (z_10 GND) capacitor c=2.406E-16
    I_C211 (Q6_12 GND) capacitor c=1.416E-16
    I_C212 (I0_t67_5 GND) capacitor c=1.219E-16
    I_C213 (XI2_Bn_2 GND) capacitor c=1.609E-16
    I_C214 (Q2_1 GND) capacitor c=2.788E-16
    I_C215 (Q7_9 GND) capacitor c=2.373E-16
    I_C216 (I1_n012_12 GND) capacitor c=9.284E-17
    I_C217 (I0_t67_3 GND) capacitor c=8.368E-17
    I_C218 (XI0_I1_An_2 GND) capacitor c=1.458E-16
    I_C219 (z_4 GND) capacitor c=8.791E-17
    I_C220 (I1_n012_16 GND) capacitor c=9.596E-17
    I_C221 (Q6_4 GND) capacitor c=1.706E-16
    I_C222 (Q6_1 GND) capacitor c=9.576E-17
    I_C223 (I1_a_11 GND) capacitor c=1.598E-16
    I_C224 (Q7_7 GND) capacitor c=3.443E-17
    I_C225 (I1_n012_2 GND) capacitor c=1.581E-16
    I_C226 (I1_a_5 GND) capacitor c=1.035E-16
    I_C227 (I1_n345_12 GND) capacitor c=5.650E-17
    I_C228 (z_2 GND) capacitor c=1.079E-16
    I_C229 (I1_n345_7 GND) capacitor c=1.032E-16
    I_C230 (Q5_2 GND) capacitor c=1.504E-16
    I_C231 (I1_a_2 GND) capacitor c=9.515E-17
    I_C232 (Q4_6 GND) capacitor c=1.448E-16
    I_C233 (I1_n345_2 GND) capacitor c=5.647E-17
    I_C234 (Q3_3 GND) capacitor c=4.067E-17
    I_C235 (XI0_I2_An_5 GND) capacitor c=1.080E-16
    I_C236 (XI0_I2_p1_4 GND) capacitor c=1.078E-18
    I_C237 (XI2_An_5 GND) capacitor c=1.072E-16
    I_C238 (XI0_I0_An_6 GND) capacitor c=1.252E-16
    I_C239 (tap_5 GND) capacitor c=1.207E-16
    I_C240 (XI2_p1_5 GND) capacitor c=7.398E-19
    I_C241 (XI0_I2_p1_2 GND) capacitor c=3.374E-18
    I_C242 (Q0_13 GND) capacitor c=4.840E-19
    I_C243 (XI2_p1_3 GND) capacitor c=1.382E-18
    I_C244 (Q5_12 GND) capacitor c=4.957E-17
    I_C245 (FB_1 GND) capacitor c=1.150E-16
    I_C246 (XI0_I1_An_6 GND) capacitor c=1.376E-16
    I_C247 (z_6 GND) capacitor c=7.821E-17
    I_C248 (Q7_5 GND) capacitor c=8.573E-17
    I_C249 (I1_a_13 GND) capacitor c=3.539E-17
    I_C250 (I1_n345_10 GND) capacitor c=9.343E-17
    I_C251 (XI0_I2_An_7 GND) capacitor c=3.656E-17
    I_C252 (XI2_An_7 GND) capacitor c=3.682E-17
    I_C253 (Q5_19 GND) capacitor c=7.195E-17
    I_C254 (I0_t05_4 GND) capacitor c=9.484E-17
    I_C255 (XI0_I2_Bn_3 GND) capacitor c=5.159E-17
    I_C256 (Q7_12 GND) capacitor c=7.445E-17
    I_C257 (I1_n012_17 GND) capacitor c=4.201E-17
    I_C258 (XI2_Bn_3 GND) capacitor c=4.726E-17
    I_C259 (I0_t67_4 GND) capacitor c=9.845E-17
    I_C260 (I1_n012_11 GND) capacitor c=3.022E-17
    I_C261 (z_3 GND) capacitor c=2.664E-17
    I_C262 (I1_a_10 GND) capacitor c=9.932E-17
    I_C263 (I1_n345_13 GND) capacitor c=3.112E-17
    I_C264 (I0_t05_12 GND) capacitor c=7.434E-17
    I_C265 (tap_14 GND) capacitor c=7.375E-17
    I_C266 (tap_10 GND) capacitor c=7.582E-17
    I_C267 (I0_t05_2 GND) capacitor c=1.163E-16
    I_C268 (FB_7 GND) capacitor c=7.268E-17
    I_C269 (I0_t67_9 GND) capacitor c=1.018E-16
    I_C270 (Q5_13 GND) capacitor c=7.241E-17
    I_C271 (Q0_1 GND) capacitor c=5.975E-17
    I_C272 (Q6_16 GND) capacitor c=1.002E-16
    I_C273 (z_9 GND) capacitor c=9.976E-17
    I_C274 (Q2_2 GND) capacitor c=1.033E-16
    I_C275 (I1_n012_13 GND) capacitor c=1.168E-16
    I_C276 (I0_t67_2 GND) capacitor c=1.203E-16
    I_C277 (z_5 GND) capacitor c=9.342E-17
    I_C278 (I1_a_12 GND) capacitor c=1.026E-16
    I_C279 (Q7_6 GND) capacitor c=9.405E-17
    I_C280 (I1_n345_11 GND) capacitor c=1.150E-16
    I_C281 (FB_5 GND) capacitor c=6.915E-17
    I_C282 (tap_12 GND) capacitor c=6.471E-17
    I_C283 (I0_t05_14 GND) capacitor c=1.858E-16
ends CFSR_FB
