// XORTAP8 sau layout: Assura RCX
simulator lang=spectre
subckt XORTAP8 Q0 Q5 Q6 Q7 FB VDD GND
    I_MXI1_MN2 (t67_8 XI1_An_5 Q7_8 GND) gpdk090_nmos1v w=0.12u l=0.1u ad=0.0468p as=0.1992p pd=0.68u ps=2.24u
    I_MXI1_MN1 (XI1_An Q7_7 t67_8 GND) gpdk090_nmos1v w=0.24u l=0.1u ad=0.0468p as=0.0468p pd=0.68u ps=0.68u
    I_MXI1_MN0 (GND Q6_4 XI1_An GND) gpdk090_nmos1v w=0.12u l=0.1u ad=0.0696p as=0.0468p pd=1.16u ps=0.68u
    I_MXI0_MN2 (t05_12 XI0_An_5 Q5_8 GND) gpdk090_nmos1v w=0.12u l=0.1u ad=0.0468p as=0.1992p pd=0.68u ps=2.24u
    I_MXI0_MN1 (XI0_An Q5_7 t05_12 GND) gpdk090_nmos1v w=0.24u l=0.1u ad=0.0468p as=0.0468p pd=0.68u ps=0.68u
    I_MXI0_MN0 (GND Q0_4 XI0_An GND) gpdk090_nmos1v w=0.12u l=0.1u ad=0.0696p as=0.0468p pd=1.16u ps=0.68u
    I_MXI2_MN1 (XI2_Bn_5 t67_16 GND GND) gpdk090_nmos1v w=0.12u l=0.1u ad=0.0696p as=0.0696p pd=1.16u ps=1.16u
    I_MXI2_MN5 (XI2_n2 XI2_Bn_3 GND GND) gpdk090_nmos1v w=0.24u l=0.1u ad=0.0528p as=0.0816p pd=0.68u ps=1.16u
    I_MXI2_MN4 (FB_3 XI2_An_7 XI2_n2 GND) gpdk090_nmos1v w=0.24u l=0.1u ad=0.0528p as=0.0528p pd=0.68u ps=0.68u
    I_MXI2_MN2 (XI2_n1 t05_18 FB_3 GND) gpdk090_nmos1v w=0.24u l=0.1u ad=0.0528p as=0.0528p pd=0.68u ps=0.68u
    I_MXI2_MN3 (GND t67_3 XI2_n1 GND) gpdk090_nmos1v w=0.24u l=0.1u ad=0.0816p as=0.0528p pd=1.16u ps=0.68u
    I_MXI2_MN0 (XI2_An t05_9 GND GND) gpdk090_nmos1v w=0.12u l=0.1u ad=0.0696p as=0.0696p pd=1.16u ps=1.16u
    I_MXI1_MP0 (VDD Q6_10 XI1_An_7 VDD) gpdk090_pmos1v w=0.24u l=0.1u ad=0.0816p as=0.0816p pd=1.16u ps=1.16u
    I_MXI1_MP1 (t67_5 Q7_6 Q6_6 VDD) gpdk090_pmos1v w=0.48u l=0.1u ad=0.0936p as=0.1632p pd=0.92u ps=1.64u
    I_MXI1_MP2 (Q7_1 Q6_3 t67_5 VDD) gpdk090_pmos1v w=0.24u l=0.1u ad=0.0816p as=0.0936p pd=1.16u ps=0.92u
    I_MXI0_MP0 (VDD Q0_10 XI0_An_6 VDD) gpdk090_pmos1v w=0.24u l=0.1u ad=0.0816p as=0.0816p pd=1.16u ps=1.16u
    I_MXI0_MP1 (t05_3 Q5_6 Q0_6 VDD) gpdk090_pmos1v w=0.48u l=0.1u ad=0.0936p as=0.1632p pd=0.92u ps=1.64u
    I_MXI0_MP2 (Q5_1 Q0_3 t05_3 VDD) gpdk090_pmos1v w=0.24u l=0.1u ad=0.0816p as=0.0936p pd=1.16u ps=0.92u
    I_MXI2_MP1 (VDD t67_17 XI2_Bn_7 VDD) gpdk090_pmos1v w=0.24u l=0.1u ad=0.0816p as=0.0816p pd=1.16u ps=1.16u
    I_MXI2_MP5 (FB_4 XI2_Bn_4 XI2_p1_6 VDD) gpdk090_pmos1v w=0.48u l=0.1u ad=0.1056p as=0.1632p pd=0.92u ps=1.64u
    I_MXI2_MP4 (XI2_p1_3 XI2_An_8 FB_4 VDD) gpdk090_pmos1v w=0.48u l=0.1u ad=0.1056p as=0.1056p pd=0.92u ps=0.92u
    I_MXI2_MP2 (VDD t05_19 XI2_p1_3 VDD) gpdk090_pmos1v w=0.48u l=0.1u ad=0.1056p as=0.1056p pd=0.92u ps=0.92u
    I_MXI2_MP3 (XI2_p1 t67_4 VDD VDD) gpdk090_pmos1v w=0.48u l=0.1u ad=0.1632p as=0.1056p pd=1.64u ps=0.92u
    I_MXI2_MP0 (VDD t05_11 XI2_An_3 VDD) gpdk090_pmos1v w=0.24u l=0.1u ad=0.0816p as=0.0816p pd=1.16u ps=1.16u
    I_Rj1 (Q0_3 Q0_1) resistor r=48.5435
    I_Rj2 (Q0_1 Q0_4) resistor r=54.5435
    I_Rj3 (t05_9 t05_10) resistor r=54.5435
    I_Rj4 (t05_10 t05_11) resistor r=48.5435
    I_Rj5 (t05_6 t05_10) resistor r=10.0000
    I_Rj6 (Q5_6 Q5_4) resistor r=36.5435
    I_Rj7 (Q5_4 Q5_7) resistor r=48.5435
    I_Rj8 (XI0_An_5 XI0_An_3) resistor r=54.5435
    I_Rj9 (t67_3 t67_2) resistor r=48.5435
    I_Rj10 (t67_2 t67_4) resistor r=36.5435
    I_Rj11 (Q0_10 Q0_7) resistor r=58.5435
    I_Rj12 (t05_18 t05_16) resistor r=48.5435
    I_Rj13 (t05_16 t05_19) resistor r=36.5435
    I_Rj14 (XI2_An_7 XI2_An_6) resistor r=48.5435
    I_Rj15 (XI2_An_6 XI2_An_8) resistor r=36.5435
    I_Rj16 (Q6_3 Q6_1) resistor r=48.5435
    I_Rj17 (Q6_1 Q6_4) resistor r=54.5435
    I_Rj18 (XI2_Bn_3 XI2_Bn) resistor r=48.5435
    I_Rj19 (XI2_Bn XI2_Bn_4) resistor r=36.5435
    I_Rj20 (Q7_6 Q7_4) resistor r=36.5435
    I_Rj21 (Q7_4 Q7_7) resistor r=48.5435
    I_Rj22 (XI1_An_5 XI1_An_3) resistor r=54.5435
    I_Rj23 (t67_16 t67_13) resistor r=54.5435
    I_Rj24 (t67_13 t67_17) resistor r=48.5435
    I_Rj25 (Q6_10 Q6_7) resistor r=58.5435
    I_Ri1 (Q5_1 Q5_2) resistor r=15.3600
    I_Ri2 (Q5_2 Q5_3) resistor r=1.5307
    I_Ri3 (Q0_1 Q0_2) resistor r=11.7360
    I_Ri4 (XI2_An XI2_An_2) resistor r=16.6347
    I_Ri5 (t05_3 t05_4) resistor r=15.3013
    I_Ri6 (t05_4 t05_5) resistor r=1.4347
    I_Ri7 (XI0_An XI0_An_2) resistor r=16.4800
    I_Ri8 (t05_6 t05_7) resistor r=6.133E-02
    I_Ri9 (t05_7 t05_8) resistor r=1.5200
    I_Ri10 (Q5_4 Q5_5) resistor r=11.5280
    I_Ri11 (XI2_An_3 XI2_An_4) resistor r=16.8907
    I_Ri12 (Q0_5 Q0_6) resistor r=16.4267
    I_Ri13 (t05_12 t05_13) resistor r=16.7893
    I_Ri14 (XI0_An_3 XI0_An_4) resistor r=11.6827
    I_Ri15 (XI2_p1 XI2_p1_2) resistor r=16.4267
    I_Ri16 (Q5_8 Q5_9) resistor r=16.6347
    I_Ri17 (t67 t67_2) resistor r=11.4267
    I_Ri18 (Q0_7 Q0_8) resistor r=6.133E-02
    I_Ri19 (Q0_8 Q0_9) resistor r=1.6747
    I_Ri20 (XI0_An_6 XI0_An_7) resistor r=17.0453
    I_Ri21 (t05_16 t05_17) resistor r=11.5813
    I_Ri22 (FB_1 FB_2) resistor r=1.4347
    I_Ri23 (FB_2 FB_3) resistor r=15.0453
    I_Ri24 (XI2_p1_3 XI2_p1_4) resistor r=16.4267
    I_Ri25 (Q7_1 Q7_2) resistor r=15.3600
    I_Ri26 (Q7_2 Q7_3) resistor r=1.5307
    I_Ri27 (XI2_An_6 XI2_An_5) resistor r=10.1280
    I_Ri28 (Q6_1 Q6_2) resistor r=11.7360
    I_Ri29 (FB_4 FB_5) resistor r=17.0453
    I_Ri30 (t67_5 t67_6) resistor r=15.3013
    I_Ri31 (t67_6 t67_7) resistor r=1.4347
    I_Ri32 (XI1_An XI1_An_2) resistor r=16.4800
    I_Ri33 (XI2_Bn XI2_Bn_2) resistor r=11.5280
    I_Ri34 (Q7_4 Q7_5) resistor r=11.5280
    I_Ri35 (XI2_p1_6 XI2_p1_5) resistor r=15.0267
    I_Ri36 (Q6_5 Q6_6) resistor r=16.4267
    I_Ri37 (t67_8 t67_9) resistor r=16.7893
    I_Ri38 (XI1_An_3 XI1_An_4) resistor r=11.6827
    I_Ri39 (XI2_Bn_5 XI2_Bn_6) resistor r=16.6347
    I_Ri40 (Q7_8 Q7_9) resistor r=16.6347
    I_Ri41 (t67_11 t67_12) resistor r=3.467E-02
    I_Ri42 (t67_12 t67_13) resistor r=10.0267
    I_Ri43 (Q6_7 Q6_8) resistor r=6.133E-02
    I_Ri44 (Q6_8 Q6_9) resistor r=1.6747
    I_Ri45 (XI2_Bn_7 XI2_Bn_8) resistor r=16.8907
    I_Ri46 (XI1_An_7 XI1_An_6) resistor r=15.6453
    I_Rh1 (t05 t05_2) resistor r=4.2844
    I_Rh2 (t05_13 t05_14) resistor r=0.1881
    I_Rh3 (t05_14 t05_5) resistor r=7.500E-03
    I_Rh4 (Q5_9 Q5_5) resistor r=0.3240
    I_Rh5 (Q5_5 Q5_3) resistor r=0.3240
    I_Rh6 (Q5_3 Q5) resistor r=2.0150
    I_Rh7 (Q0 Q0_11) resistor r=1.5567
    I_Rh8 (Q0_11 Q0_5) resistor r=0.2580
    I_Rh9 (Q0_5 Q0_2) resistor r=0.3240
    I_Rh10 (Q0_11 Q0_9) resistor r=5.798E-02
    I_Rh11 (t05_17 t05_8) resistor r=0.6480
    I_Rh12 (t05_8 t05_15) resistor r=0.1442
    I_Rh13 (XI0_An_7 XI0_An_4) resistor r=0.3240
    I_Rh14 (XI0_An_4 XI0_An_2) resistor r=0.3240
    I_Rh15 (XI2_An_5 XI2_An_4) resistor r=2.1560
    I_Rh16 (XI2_An_4 XI2_An_2) resistor r=0.2160
    I_Rh17 (FB FB_6) resistor r=2.8268
    I_Rh18 (FB_1 FB_7) resistor r=0.1652
    I_Rh19 (FB_7 FB_5) resistor r=1.500E-02
    I_Rh20 (XI2_p1_5 XI2_p1_4) resistor r=1.8320
    I_Rh21 (XI2_p1_4 XI2_p1_2) resistor r=0.4320
    I_Rh22 (t67_7 t67_10) resistor r=0.1909
    I_Rh23 (t67_10 t67_9) resistor r=3.000E-03
    I_Rh24 (t67_14 t67) resistor r=1.0800
    I_Rh25 (t67_14 t67_15) resistor r=1.5470
    I_Rh26 (t67_12 t67_14) resistor r=1.4000
    I_Rh27 (Q7_9 Q7_5) resistor r=0.3240
    I_Rh28 (Q7_5 Q7_10) resistor r=0.2439
    I_Rh29 (Q7_10 Q7) resistor r=1.9286
    I_Rh30 (Q7_10 Q7_3) resistor r=7.592E-02
    I_Rh31 (Q6 Q6_9) resistor r=1.4995
    I_Rh32 (Q6_9 Q6_5) resistor r=0.3240
    I_Rh33 (Q6_5 Q6_2) resistor r=0.3240
    I_Rh34 (XI2_Bn_8 XI2_Bn_6) resistor r=0.2160
    I_Rh35 (XI2_Bn_6 XI2_Bn_2) resistor r=0.3240
    I_Rh36 (XI1_An_6 XI1_An_4) resistor r=1.7240
    I_Rh37 (XI1_An_4 XI1_An_2) resistor r=0.3240
    I_Rh38 (t67_18 t67_19) resistor r=4.1601
    I_Rg1 (t05_14 t05) resistor r=1.8901
    I_Rg2 (t05_15 t05_2) resistor r=1.8901
    I_Rg3 (FB_7 FB_6) resistor r=2.0612
    I_Rg4 (t67_18 t67_10) resistor r=2.0144
    I_Rg5 (t67_19 t67_15) resistor r=0.3658
    I_C1 (VDD GND) capacitor c=5.376E-15
    I_C2 (FB GND) capacitor c=1.508E-16
    I_C3 (Q0 GND) capacitor c=2.081E-16
    I_C4 (Q5 GND) capacitor c=2.034E-16
    I_C5 (Q6 GND) capacitor c=1.660E-16
    I_C6 (Q7 GND) capacitor c=2.429E-16
    I_C7 (t05 GND) capacitor c=2.283E-16
    I_C8 (t67 GND) capacitor c=3.888E-16
    I_C9 (XI1_An GND) capacitor c=4.218E-17
    I_C10 (XI0_An GND) capacitor c=4.353E-17
    I_C11 (XI2_p1 GND) capacitor c=1.292E-20
    I_C12 (XI2_n1 GND) capacitor c=9.541E-19
    I_C13 (XI2_n2 GND) capacitor c=8.064E-18
    I_C14 (XI2_An GND) capacitor c=3.950E-17
    I_C15 (XI2_Bn GND) capacitor c=1.002E-16
    I_C16 (Q6_10 GND) capacitor c=5.195E-17
    I_C17 (t67_17 GND) capacitor c=5.997E-17
    I_C18 (Q7_6 GND) capacitor c=6.446E-17
    I_C19 (XI2_Bn_4 GND) capacitor c=5.990E-17
    I_C20 (Q6_3 GND) capacitor c=4.771E-17
    I_C21 (XI2_An_8 GND) capacitor c=6.423E-17
    I_C22 (t05_19 GND) capacitor c=5.846E-17
    I_C23 (Q0_10 GND) capacitor c=5.840E-17
    I_C24 (t67_4 GND) capacitor c=7.088E-17
    I_C25 (Q5_6 GND) capacitor c=6.325E-17
    I_C26 (t05_11 GND) capacitor c=5.189E-17
    I_C27 (Q0_3 GND) capacitor c=3.852E-17
    I_C28 (t67_16 GND) capacitor c=5.354E-17
    I_C29 (XI1_An_5 GND) capacitor c=3.796E-17
    I_C30 (Q7_7 GND) capacitor c=6.126E-17
    I_C31 (XI2_Bn_3 GND) capacitor c=5.386E-17
    I_C32 (Q6_4 GND) capacitor c=5.908E-17
    I_C33 (XI2_An_7 GND) capacitor c=5.769E-17
    I_C34 (t05_18 GND) capacitor c=5.910E-17
    I_C35 (t67_3 GND) capacitor c=5.865E-17
    I_C36 (XI0_An_5 GND) capacitor c=4.351E-17
    I_C37 (Q5_7 GND) capacitor c=6.276E-17
    I_C38 (t05_9 GND) capacitor c=5.046E-17
    I_C39 (Q0_4 GND) capacitor c=5.680E-17
    I_C40 (t67_18 GND) capacitor c=2.089E-16
    I_C41 (t67_19 GND) capacitor c=1.465E-16
    I_C42 (t67_15 GND) capacitor c=6.687E-17
    I_C43 (t67_10 GND) capacitor c=1.427E-16
    I_C44 (FB_7 GND) capacitor c=1.168E-16
    I_C45 (FB_6 GND) capacitor c=2.172E-16
    I_C46 (t05_14 GND) capacitor c=4.711E-17
    I_C47 (t05_15 GND) capacitor c=7.486E-17
    I_C48 (t05_2 GND) capacitor c=1.413E-16
    I_C49 (Q6_7 GND) capacitor c=5.215E-17
    I_C50 (t67_13 GND) capacitor c=6.374E-17
    I_C51 (XI1_An_3 GND) capacitor c=1.416E-16
    I_C52 (Q7_4 GND) capacitor c=1.266E-16
    I_C53 (Q6_1 GND) capacitor c=1.747E-16
    I_C54 (XI2_An_6 GND) capacitor c=1.072E-16
    I_C55 (t05_16 GND) capacitor c=9.716E-17
    I_C56 (Q0_7 GND) capacitor c=5.454E-17
    I_C57 (t67_2 GND) capacitor c=5.531E-17
    I_C58 (XI0_An_3 GND) capacitor c=1.436E-16
    I_C59 (Q5_4 GND) capacitor c=1.273E-16
    I_C60 (t05_6 GND) capacitor c=6.194E-17
    I_C61 (Q0_1 GND) capacitor c=1.768E-16
    I_C62 (XI1_An_6 GND) capacitor c=1.735E-16
    I_C63 (Q6_9 GND) capacitor c=2.391E-16
    I_C64 (XI2_Bn_8 GND) capacitor c=1.554E-16
    I_C65 (Q7_9 GND) capacitor c=1.766E-16
    I_C66 (t67_12 GND) capacitor c=2.277E-16
    I_C67 (XI1_An_4 GND) capacitor c=2.018E-16
    I_C68 (XI2_Bn_6 GND) capacitor c=1.276E-16
    I_C69 (Q6_5 GND) capacitor c=1.345E-16
    I_C70 (t67_9 GND) capacitor c=1.207E-16
    I_C71 (Q7_5 GND) capacitor c=2.018E-16
    I_C72 (XI2_p1_5 GND) capacitor c=1.331E-16
    I_C73 (t67_7 GND) capacitor c=7.778E-17
    I_C74 (XI1_An_2 GND) capacitor c=1.364E-16
    I_C75 (XI2_Bn_2 GND) capacitor c=1.323E-16
    I_C76 (Q6_2 GND) capacitor c=1.515E-16
    I_C77 (FB_5 GND) capacitor c=1.476E-16
    I_C78 (Q7_3 GND) capacitor c=5.018E-17
    I_C79 (XI2_An_5 GND) capacitor c=2.728E-16
    I_C80 (FB_1 GND) capacitor c=1.348E-16
    I_C81 (XI2_p1_4 GND) capacitor c=2.265E-16
    I_C82 (XI0_An_7 GND) capacitor c=1.614E-16
    I_C83 (t05_17 GND) capacitor c=2.652E-16
    I_C84 (Q0_9 GND) capacitor c=9.340E-17
    I_C85 (Q5_9 GND) capacitor c=1.779E-16
    I_C86 (XI0_An_4 GND) capacitor c=2.002E-16
    I_C87 (XI2_p1_2 GND) capacitor c=1.683E-16
    I_C88 (Q0_5 GND) capacitor c=1.222E-16
    I_C89 (t05_13 GND) capacitor c=2.029E-16
    I_C90 (Q5_5 GND) capacitor c=2.322E-16
    I_C91 (XI2_An_4 GND) capacitor c=2.094E-16
    I_C92 (t05_5 GND) capacitor c=8.179E-17
    I_C93 (XI0_An_2 GND) capacitor c=1.359E-16
    I_C94 (t05_8 GND) capacitor c=1.254E-16
    I_C95 (Q0_2 GND) capacitor c=1.550E-16
    I_C96 (XI2_An_2 GND) capacitor c=8.623E-17
    I_C97 (Q5_3 GND) capacitor c=2.950E-16
    I_C98 (XI1_An_7 GND) capacitor c=1.275E-16
    I_C99 (XI2_Bn_7 GND) capacitor c=8.166E-17
    I_C100 (t67_5 GND) capacitor c=7.895E-17
    I_C101 (FB_4 GND) capacitor c=1.104E-16
    I_C102 (Q7_1 GND) capacitor c=7.226E-17
    I_C103 (XI2_p1_3 GND) capacitor c=1.039E-18
    I_C104 (XI0_An_6 GND) capacitor c=1.340E-16
    I_C105 (Q0_6 GND) capacitor c=6.222E-20
    I_C106 (XI2_An_3 GND) capacitor c=1.120E-16
    I_C107 (t05_3 GND) capacitor c=7.458E-17
    I_C108 (Q5_1 GND) capacitor c=6.131E-17
    I_C109 (Q7_8 GND) capacitor c=7.500E-17
    I_C110 (XI2_Bn_5 GND) capacitor c=4.564E-17
    I_C111 (t67_8 GND) capacitor c=9.855E-17
    I_C112 (FB_3 GND) capacitor c=1.739E-19
    I_C113 (Q5_8 GND) capacitor c=7.398E-17
    I_C114 (t05_12 GND) capacitor c=9.900E-17
    I_C115 (Q6_8 GND) capacitor c=9.894E-17
    I_C116 (t67_11 GND) capacitor c=9.763E-17
    I_C117 (t67_6 GND) capacitor c=1.200E-16
    I_C118 (Q7_2 GND) capacitor c=8.088E-17
    I_C119 (Q0_8 GND) capacitor c=9.924E-17
    I_C120 (t05_4 GND) capacitor c=1.170E-16
    I_C121 (t05_7 GND) capacitor c=6.773E-17
    I_C122 (Q5_2 GND) capacitor c=7.674E-17
    I_C123 (Q0_11 GND) capacitor c=1.822E-16
    I_C124 (Q7_10 GND) capacitor c=2.158E-16
ends XORTAP8
