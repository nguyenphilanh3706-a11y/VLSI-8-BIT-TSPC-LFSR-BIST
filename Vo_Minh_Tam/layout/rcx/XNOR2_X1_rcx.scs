// XNOR2_X1 sau layout: Assura RCX
simulator lang=spectre
subckt XNOR2_X1 A B Y VDD GND
    I_MN1 (Bn_3 B_4 GND GND) gpdk090_nmos1v w=0.12u l=0.1u ad=0.0696p as=0.0792p pd=1.16u ps=1.22u
    I_MN3 (n1 Bn_7 GND GND) gpdk090_nmos1v w=0.24u l=0.1u ad=0.0528p as=0.0792p pd=0.68u ps=1.22u
    I_MN2 (Y_3 A_4 n1 GND) gpdk090_nmos1v w=0.24u l=0.1u ad=0.0528p as=0.0528p pd=0.68u ps=0.68u
    I_MN4 (Y_3 An_4 n2 GND) gpdk090_nmos1v w=0.24u l=0.1u ad=0.0528p as=0.0528p pd=0.68u ps=0.68u
    I_MN5 (n2 B_10 GND GND) gpdk090_nmos1v w=0.24u l=0.1u ad=0.0528p as=0.0468p pd=0.68u ps=0.68u
    I_MN0 (An_7 A_9 GND GND) gpdk090_nmos1v w=0.12u l=0.1u ad=0.0696p as=0.0468p pd=1.16u ps=0.68u
    I_MP1 (Bn B_3 VDD VDD) gpdk090_pmos1v w=0.24u l=0.1u ad=0.0816p as=0.0936p pd=1.16u ps=0.92u
    I_MP3 (p1_2 B_7 VDD VDD) gpdk090_pmos1v w=0.48u l=0.1u ad=0.1056p as=0.0936p pd=0.92u ps=0.92u
    I_MP5 (Y_1 Bn_6 p1_2 VDD) gpdk090_pmos1v w=0.48u l=0.1u ad=0.1056p as=0.1056p pd=0.92u ps=0.92u
    I_MP4 (Y_1 A_3 p1_4 VDD) gpdk090_pmos1v w=0.48u l=0.1u ad=0.1056p as=0.1056p pd=0.92u ps=0.92u
    I_MP2 (p1_4 An_3 VDD VDD) gpdk090_pmos1v w=0.48u l=0.1u ad=0.1056p as=0.1584p pd=0.92u ps=1.46u
    I_MP0 (An_5 A_7 VDD VDD) gpdk090_pmos1v w=0.24u l=0.1u ad=0.0816p as=0.1584p pd=1.16u ps=1.46u
    I_Rj1 (B_3 B_1) resistor r=48.5435
    I_Rj2 (B_1 B_4) resistor r=54.5435
    I_Rj3 (B_7 B_5) resistor r=36.5435
    I_Rj4 (Bn_6 Bn_4) resistor r=36.5435
    I_Rj5 (Bn_4 Bn_7) resistor r=48.5435
    I_Rj6 (A_3 A_1) resistor r=36.5435
    I_Rj7 (A_1 A_4) resistor r=48.5435
    I_Rj8 (An_3 An) resistor r=36.5435
    I_Rj9 (An An_4) resistor r=48.5435
    I_Rj10 (B_10 B_8) resistor r=48.5435
    I_Rj11 (A_7 A_8) resistor r=48.5435
    I_Rj12 (A_8 A_9) resistor r=54.5435
    I_Rj13 (A_5 A_8) resistor r=10.0000
    I_Ri1 (Bn Bn_2) resistor r=15.4907
    I_Ri2 (Bn_2 Bn_3) resistor r=15.2347
    I_Ri3 (B_1 B_2) resistor r=10.0267
    I_Ri4 (B_2 B) resistor r=3.467E-02
    I_Ri5 (B_5 B_6) resistor r=11.4267
    I_Ri6 (p1 p1_2) resistor r=16.4267
    I_Ri7 (Bn_4 Bn_5) resistor r=11.5280
    I_Ri8 (Y_1 Y_2) resistor r=17.0453
    I_Ri9 (A_1 A_2) resistor r=11.5280
    I_Ri10 (p1_3 p1_4) resistor r=16.4267
    I_Ri11 (Y_3 Y) resistor r=15.0453
    I_Ri12 (Y Y_4) resistor r=1.4347
    I_Ri13 (An An_2) resistor r=11.5813
    I_Ri14 (B_8 B_9) resistor r=11.4267
    I_Ri15 (A_5 A) resistor r=1.333E-02
    I_Ri16 (A A_6) resistor r=1.5147
    I_Ri17 (An_5 An_6) resistor r=15.1813
    I_Ri18 (An_6 An_7) resistor r=15.5440
    I_Rh1 (Bn_5 Bn_2) resistor r=1.9400
    I_Rh2 (Y_4 Y_2) resistor r=0.2160
    I_Rh3 (p1_3 p1) resistor r=0.4320
    I_Rh4 (B_9 B_6) resistor r=0.8640
    I_Rh5 (B_6 B_2) resistor r=1.6160
    I_Rh6 (A_6 A_2) resistor r=0.6480
    I_Rh7 (An_6 An_2) resistor r=1.9400
    I_C1 (VDD GND) capacitor c=5.587E-16
    I_C2 (A GND) capacitor c=5.471E-17
    I_C3 (Y GND) capacitor c=7.699E-17
    I_C4 (p1 GND) capacitor c=1.274E-16
    I_C5 (n1 GND) capacitor c=1.071E-17
    I_C6 (An GND) capacitor c=9.671E-17
    I_C7 (Bn GND) capacitor c=6.949E-17
    I_C8 (B_3 GND) capacitor c=4.838E-17
    I_C9 (B_7 GND) capacitor c=5.727E-17
    I_C10 (Bn_6 GND) capacitor c=6.490E-17
    I_C11 (A_3 GND) capacitor c=6.371E-17
    I_C12 (An_3 GND) capacitor c=5.723E-17
    I_C13 (A_7 GND) capacitor c=6.260E-17
    I_C14 (B_4 GND) capacitor c=5.305E-17
    I_C15 (Bn_7 GND) capacitor c=5.991E-17
    I_C16 (A_4 GND) capacitor c=5.375E-17
    I_C17 (An_4 GND) capacitor c=5.677E-17
    I_C18 (B_10 GND) capacitor c=5.871E-17
    I_C19 (A_9 GND) capacitor c=5.469E-17
    I_C20 (B_1 GND) capacitor c=1.275E-16
    I_C21 (B_5 GND) capacitor c=7.739E-17
    I_C22 (Bn_4 GND) capacitor c=1.090E-16
    I_C23 (A_1 GND) capacitor c=1.068E-16
    I_C24 (B_8 GND) capacitor c=1.242E-16
    I_C25 (A_5 GND) capacitor c=6.478E-17
    I_C26 (Bn_2 GND) capacitor c=1.927E-16
    I_C27 (B_2 GND) capacitor c=6.222E-17
    I_C28 (B_6 GND) capacitor c=2.079E-16
    I_C29 (Bn_5 GND) capacitor c=1.727E-16
    I_C30 (Y_2 GND) capacitor c=2.052E-16
    I_C31 (A_2 GND) capacitor c=2.527E-16
    I_C32 (Y_4 GND) capacitor c=6.089E-17
    I_C33 (p1_3 GND) capacitor c=1.369E-16
    I_C34 (An_2 GND) capacitor c=1.691E-16
    I_C35 (B_9 GND) capacitor c=2.656E-16
    I_C36 (A_6 GND) capacitor c=1.548E-16
    I_C37 (An_6 GND) capacitor c=1.526E-16
    I_C38 (Y_1 GND) capacitor c=1.224E-16
    I_C39 (p1_4 GND) capacitor c=3.052E-18
    I_C40 (An_5 GND) capacitor c=3.139E-17
    I_C41 (Bn_3 GND) capacitor c=3.110E-17
    I_C42 (An_7 GND) capacitor c=8.524E-17
ends XNOR2_X1
