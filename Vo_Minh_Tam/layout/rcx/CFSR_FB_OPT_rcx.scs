// CFSR_FB_OPT sau layout: Assura RCX
simulator lang=spectre
subckt CFSR_FB_OPT Q0 Q1 Q2 Q3 Q4 Q5 Q6 Q7 FB VDD GND
    I_MXI5_MN1 (GND wn_12 XI5_Bn_6 GND) gpdk090_nmos1v w=0.12u l=0.1u ad=0.0792p as=0.0696p pd=1.22u ps=1.16u
    I_MXI5_MN3 (XI5_n1 XI5_Bn_3 GND GND) gpdk090_nmos1v w=0.24u l=0.1u ad=0.0528p as=0.0792p pd=0.68u ps=1.22u
    I_MXI5_MN2 (FB_3 t67_13 XI5_n1 GND) gpdk090_nmos1v w=0.24u l=0.1u ad=0.0528p as=0.0528p pd=0.68u ps=0.68u
    I_MXI5_MN4 (XI5_n2 XI5_An_6 FB_3 GND) gpdk090_nmos1v w=0.24u l=0.1u ad=0.0528p as=0.0528p pd=0.68u ps=0.68u
    I_MXI5_MN5 (GND wn_3 XI5_n2 GND) gpdk090_nmos1v w=0.24u l=0.1u ad=0.0468p as=0.0528p pd=0.68u ps=0.68u
    I_MXI5_MN0 (XI5_An t67_4 GND GND) gpdk090_nmos1v w=0.12u l=0.1u ad=0.0696p as=0.0468p pd=1.16u ps=0.68u
    I_MXI0_MN2 (t05_4 XI0_An_5 Q5_8 GND) gpdk090_nmos1v w=0.12u l=0.1u ad=0.0468p as=0.1992p pd=0.68u ps=2.24u
    I_MXI0_MN1 (XI0_An Q5_7 t05_4 GND) gpdk090_nmos1v w=0.24u l=0.1u ad=0.0468p as=0.0468p pd=0.68u ps=0.68u
    I_MXI0_MN0 (GND Q0_6 XI0_An GND) gpdk090_nmos1v w=0.12u l=0.1u ad=0.0696p as=0.0468p pd=1.16u ps=0.68u
    I_MXI1_MN2 (t67_7 XI1_An_5 Q7_1 GND) gpdk090_nmos1v w=0.12u l=0.1u ad=0.0468p as=0.1992p pd=0.68u ps=2.24u
    I_MXI1_MN1 (XI1_An_6 Q7_6 t67_7 GND) gpdk090_nmos1v w=0.24u l=0.1u ad=0.0468p as=0.0468p pd=0.68u ps=0.68u
    I_MXI1_MN0 (GND Q6_12 XI1_An_6 GND) gpdk090_nmos1v w=0.12u l=0.1u ad=0.0696p as=0.0468p pd=1.16u ps=0.68u
    I_MXI3_MN2 (GND Q6_18 n346 GND) gpdk090_nmos1v w=0.12u l=0.1u ad=0.0408p as=0.0696p pd=0.68u ps=1.16u
    I_MXI3_MN1 (n346_13 Q4_5 GND GND) gpdk090_nmos1v w=0.12u l=0.1u ad=0.0408p as=0.0408p pd=0.68u ps=0.68u
    I_MXI3_MN0 (GND Q3_1 n346_13 GND) gpdk090_nmos1v w=0.12u l=0.1u ad=0.0696p as=0.0408p pd=1.16u ps=0.68u
    I_MXI2_MN2 (GND Q2_4 n012_3 GND) gpdk090_nmos1v w=0.12u l=0.1u ad=0.0408p as=0.0696p pd=0.68u ps=1.16u
    I_MXI2_MN1 (n012 Q1_4 GND GND) gpdk090_nmos1v w=0.12u l=0.1u ad=0.0408p as=0.0408p pd=0.68u ps=0.68u
    I_MXI2_MN0 (GND Q0_13 n012 GND) gpdk090_nmos1v w=0.12u l=0.1u ad=0.0696p as=0.0408p pd=1.16u ps=0.68u
    I_MXI4_MN2 (GND t05_13 wn_18 GND) gpdk090_nmos1v w=0.12u l=0.1u ad=0.0468p as=0.0696p pd=0.68u ps=1.16u
    I_MXI4_MN1 (XI4_n1 n346_10 GND GND) gpdk090_nmos1v w=0.24u l=0.1u ad=0.0528p as=0.0468p pd=0.68u ps=0.68u
    I_MXI4_MN0 (wn_23 n012_13 XI4_n1 GND) gpdk090_nmos1v w=0.24u l=0.1u ad=0.0816p as=0.0528p pd=1.16u ps=0.68u
    I_MXI5_MP1 (VDD wn_13 XI5_Bn_7 VDD) gpdk090_pmos1v w=0.24u l=0.1u ad=0.0936p as=0.0816p pd=0.92u ps=1.16u
    I_MXI5_MP3 (XI5_p1_3 wn_6 VDD VDD) gpdk090_pmos1v w=0.48u l=0.1u ad=0.1056p as=0.0936p pd=0.92u ps=0.92u
    I_MXI5_MP5 (FB_4 XI5_Bn_4 XI5_p1_3 VDD) gpdk090_pmos1v w=0.48u l=0.1u ad=0.1056p as=0.1056p pd=0.92u ps=0.92u
    I_MXI5_MP4 (XI5_p1 t67_14 FB_4 VDD) gpdk090_pmos1v w=0.48u l=0.1u ad=0.1056p as=0.1056p pd=0.92u ps=0.92u
    I_MXI5_MP2 (VDD XI5_An_7 XI5_p1 VDD) gpdk090_pmos1v w=0.48u l=0.1u ad=0.1584p as=0.1056p pd=1.46u ps=0.92u
    I_MXI5_MP0 (XI5_An_3 t67_6 VDD VDD) gpdk090_pmos1v w=0.24u l=0.1u ad=0.0816p as=0.1584p pd=1.16u ps=1.46u
    I_MXI0_MP0 (VDD Q0_21 XI0_An_6 VDD) gpdk090_pmos1v w=0.24u l=0.1u ad=0.0816p as=0.0816p pd=1.16u ps=1.16u
    I_MXI0_MP1 (t05 Q5_6 Q0_8 VDD) gpdk090_pmos1v w=0.48u l=0.1u ad=0.0936p as=0.1632p pd=0.92u ps=1.64u
    I_MXI0_MP2 (Q5_1 Q0_5 t05 VDD) gpdk090_pmos1v w=0.24u l=0.1u ad=0.0816p as=0.0936p pd=1.16u ps=0.92u
    I_MXI1_MP0 (VDD Q6_4 XI1_An VDD) gpdk090_pmos1v w=0.24u l=0.1u ad=0.0816p as=0.0816p pd=1.16u ps=1.16u
    I_MXI1_MP1 (t67_16 Q7_5 Q6_6 VDD) gpdk090_pmos1v w=0.48u l=0.1u ad=0.0936p as=0.1632p pd=0.92u ps=1.64u
    I_MXI1_MP2 (Q7_10 Q6_11 t67_16 VDD) gpdk090_pmos1v w=0.24u l=0.1u ad=0.0816p as=0.0936p pd=1.16u ps=0.92u
    I_MXI3_MP2 (XI3_p1 Q6_20 n346_4 VDD) gpdk090_pmos1v w=0.48u l=0.1u ad=0.1056p as=0.1632p pd=0.92u ps=1.64u
    I_MXI3_MP1 (XI3_p2 Q4_7 XI3_p1 VDD) gpdk090_pmos1v w=0.48u l=0.1u ad=0.1056p as=0.1056p pd=0.92u ps=0.92u
    I_MXI3_MP0 (VDD Q3_3 XI3_p2 VDD) gpdk090_pmos1v w=0.48u l=0.1u ad=0.1632p as=0.1056p pd=1.64u ps=0.92u
    I_MXI2_MP2 (XI2_p1 Q2_6 n012_6 VDD) gpdk090_pmos1v w=0.48u l=0.1u ad=0.1056p as=0.1632p pd=0.92u ps=1.64u
    I_MXI2_MP1 (XI2_p2 Q1_6 XI2_p1 VDD) gpdk090_pmos1v w=0.48u l=0.1u ad=0.1056p as=0.1056p pd=0.92u ps=0.92u
    I_MXI2_MP0 (VDD Q0_15 XI2_p2 VDD) gpdk090_pmos1v w=0.48u l=0.1u ad=0.1632p as=0.1056p pd=1.64u ps=0.92u
    I_MXI4_MP2 (XI4_p1_2 t05_11 wn_15 VDD) gpdk090_pmos1v w=0.48u l=0.1u ad=0.1056p as=0.1632p pd=0.92u ps=1.64u
    I_MXI4_MP1 (VDD n346_8 XI4_p1_2 VDD) gpdk090_pmos1v w=0.48u l=0.1u ad=0.1056p as=0.1056p pd=0.92u ps=0.92u
    I_MXI4_MP0 (XI4_p1_4 n012_12 VDD VDD) gpdk090_pmos1v w=0.48u l=0.1u ad=0.1632p as=0.1056p pd=1.64u ps=0.92u
    I_Rj1 (t67_4 t67_5) resistor r=54.5435
    I_Rj2 (t67_5 t67_6) resistor r=48.5435
    I_Rj3 (t67 t67_5) resistor r=10.0000
    I_Rj4 (wn_3 wn_2) resistor r=48.5435
    I_Rj5 (Q6_4 Q6_1) resistor r=58.5435
    I_Rj6 (XI5_An_6 XI5_An_4) resistor r=48.5435
    I_Rj7 (XI5_An_4 XI5_An_7) resistor r=36.5435
    I_Rj8 (XI1_An_5 XI1_An_3) resistor r=54.5435
    I_Rj9 (t67_13 t67_9) resistor r=48.5435
    I_Rj10 (t67_9 t67_14) resistor r=36.5435
    I_Rj11 (Q7_5 Q7_3) resistor r=36.5435
    I_Rj12 (Q7_3 Q7_6) resistor r=48.5435
    I_Rj13 (XI5_Bn_3 XI5_Bn) resistor r=48.5435
    I_Rj14 (XI5_Bn XI5_Bn_4) resistor r=36.5435
    I_Rj15 (Q6_11 Q6_7) resistor r=48.5435
    I_Rj16 (Q6_7 Q6_12) resistor r=54.5435
    I_Rj17 (wn_6 wn_5) resistor r=36.5435
    I_Rj18 (wn_12 wn_9) resistor r=54.5435
    I_Rj19 (wn_9 wn_13) resistor r=48.5435
    I_Rj20 (Q0_5 Q0_1) resistor r=48.5435
    I_Rj21 (Q0_1 Q0_6) resistor r=54.5435
    I_Rj22 (Q5_6 Q5_4) resistor r=36.5435
    I_Rj23 (Q5_4 Q5_7) resistor r=48.5435
    I_Rj24 (Q0_13 Q0_14) resistor r=54.5435
    I_Rj25 (Q0_14 Q0_15) resistor r=36.5435
    I_Rj26 (Q0_9 Q0_14) resistor r=10.0000
    I_Rj27 (XI0_An_5 XI0_An_3) resistor r=54.5435
    I_Rj28 (Q1_4 Q1_5) resistor r=54.5435
    I_Rj29 (Q1_5 Q1_6) resistor r=36.5435
    I_Rj30 (Q1_1 Q1_5) resistor r=10.0000
    I_Rj31 (Q0_21 Q0_17) resistor r=58.5435
    I_Rj32 (Q2_4 Q2_5) resistor r=54.5435
    I_Rj33 (Q2_5 Q2_6) resistor r=36.5435
    I_Rj34 (Q2_1 Q2_5) resistor r=10.0000
    I_Rj35 (t05_11 t05_12) resistor r=36.5435
    I_Rj36 (t05_12 t05_13) resistor r=54.5435
    I_Rj37 (t05_8 t05_12) resistor r=10.0000
    I_Rj38 (Q6_18 Q6_19) resistor r=54.5435
    I_Rj39 (Q6_19 Q6_20) resistor r=36.5435
    I_Rj40 (n346_8 n346_9) resistor r=36.5435
    I_Rj41 (n346_9 n346_10) resistor r=48.5435
    I_Rj42 (n346_5 n346_9) resistor r=10.0000
    I_Rj43 (Q4_5 Q4_6) resistor r=54.5435
    I_Rj44 (Q4_6 Q4_7) resistor r=36.5435
    I_Rj45 (Q4_1 Q4_6) resistor r=10.0000
    I_Rj46 (n012_12 n012_9) resistor r=36.5435
    I_Rj47 (n012_9 n012_13) resistor r=48.5435
    I_Rj48 (Q3_1 Q3_2) resistor r=54.5435
    I_Rj49 (Q3_2 Q3_3) resistor r=36.5435
    I_Ri1 (XI5_An XI5_An_2) resistor r=15.5440
    I_Ri2 (XI5_An_2 XI5_An_3) resistor r=15.1813
    I_Ri3 (t67 t67_2) resistor r=1.333E-02
    I_Ri4 (t67_2 t67_3) resistor r=1.5147
    I_Ri5 (XI1_An XI1_An_2) resistor r=17.0453
    I_Ri6 (wn wn_2) resistor r=11.4267
    I_Ri7 (Q6_1 Q6_2) resistor r=6.133E-02
    I_Ri8 (Q6_2 Q6_3) resistor r=1.6747
    I_Ri9 (Q7_1 Q7_2) resistor r=16.6347
    I_Ri10 (XI5_An_4 XI5_An_5) resistor r=11.5813
    I_Ri11 (XI1_An_3 XI1_An_4) resistor r=11.6827
    I_Ri12 (FB_1 FB_2) resistor r=1.4347
    I_Ri13 (FB_2 FB_3) resistor r=15.0453
    I_Ri14 (XI5_p1 XI5_p1_2) resistor r=16.4267
    I_Ri15 (Q6_5 Q6_6) resistor r=16.4267
    I_Ri16 (t67_7 t67_8) resistor r=16.7893
    I_Ri17 (t67_9 t67_10) resistor r=11.5280
    I_Ri18 (Q7_3 Q7_4) resistor r=11.5280
    I_Ri19 (FB_4 FB_5) resistor r=17.0453
    I_Ri20 (t67_16 t67_17) resistor r=15.3013
    I_Ri21 (t67_17 t67_18) resistor r=1.4347
    I_Ri22 (XI1_An_6 XI1_An_7) resistor r=16.4800
    I_Ri23 (XI5_Bn XI5_Bn_2) resistor r=11.5280
    I_Ri24 (Q6_7 Q6_8) resistor r=11.7360
    I_Ri25 (XI5_p1_3 XI5_p1_4) resistor r=16.4267
    I_Ri26 (Q7_10 Q7_11) resistor r=15.3600
    I_Ri27 (Q7_11 Q7_7) resistor r=1.5307
    I_Ri28 (wn_4 wn_5) resistor r=11.4267
    I_Ri29 (Q5_1 Q5_2) resistor r=15.3600
    I_Ri30 (Q5_2 Q5_3) resistor r=1.5307
    I_Ri31 (wn_7 wn_8) resistor r=3.467E-02
    I_Ri32 (wn_8 wn_9) resistor r=10.0267
    I_Ri33 (Q0_1 Q0_2) resistor r=11.7360
    I_Ri34 (XI5_Bn_6 XI5_Bn_5) resistor r=15.2347
    I_Ri35 (XI5_Bn_5 XI5_Bn_7) resistor r=15.4907
    I_Ri36 (t05 t05_2) resistor r=15.3013
    I_Ri37 (t05_2 t05_3) resistor r=1.4347
    I_Ri38 (XI0_An XI0_An_2) resistor r=16.4800
    I_Ri39 (Q5_4 Q5_5) resistor r=11.5280
    I_Ri40 (Q0_7 Q0_8) resistor r=16.4267
    I_Ri41 (t05_4 t05_5) resistor r=16.7893
    I_Ri43 (Q0_9 Q0_11) resistor r=1.250E-02
    I_Ri44 (XI0_An_3 XI0_An_4) resistor r=11.6827
    I_Ri45 (n012 n012_2) resistor r=16.4800
    I_Ri46 (Q5_8 Q5_9) resistor r=16.6347
    I_Ri48 (Q1_1 Q1_3) resistor r=5.833E-03
    I_Ri49 (Q0_17 Q0_18) resistor r=6.133E-02
    I_Ri50 (Q0_18 Q0_19) resistor r=1.6747
    I_Ri51 (XI0_An_6 XI0_An_7) resistor r=17.0453
    I_Ri53 (Q2_1 Q2_3) resistor r=1.167E-02
    I_Ri54 (n012_3 n012_4) resistor r=15.0800
    I_Ri55 (n012_4 n012_5) resistor r=6.667E-02
    I_Ri56 (n012_5 n012_6) resistor r=15.5787
    I_Ri57 (wn_15 wn_16) resistor r=15.5787
    I_Ri58 (wn_16 wn_17) resistor r=6.667E-02
    I_Ri59 (wn_17 wn_18) resistor r=15.0800
    I_Ri60 (n346 n346_2) resistor r=15.0800
    I_Ri61 (n346_2 n346_3) resistor r=6.667E-02
    I_Ri62 (n346_3 n346_4) resistor r=15.5787
    I_Ri64 (t05_8 t05_10) resistor r=1.083E-02
    I_Ri65 (XI4_p1 XI4_p1_2) resistor r=16.4267
    I_Ri66 (Q6_21 Q6_22) resistor r=2.667E-03
    I_Ri67 (Q6_21 Q6_17) resistor r=4.741E-02
    I_Ri68 (Q6_19 Q6_22) resistor r=10.0000
    I_Ri70 (n346_5 n346_7) resistor r=6.667E-03
    I_Ri72 (Q4_1 Q4_3) resistor r=3.333E-03
    I_Ri73 (n346_13 n346_14) resistor r=16.4800
    I_Ri74 (n012_9 n012_10) resistor r=10.0000
    I_Ri76 (XI4_p1_3 XI4_p1_4) resistor r=15.0267
    I_Ri77 (wn_23 wn_21) resistor r=15.0800
    I_Ri78 (Q3_4 Q3_5) resistor r=2.667E-03
    I_Ri79 (Q3_4 Q3_6) resistor r=1.4474
    I_Ri80 (Q3_2 Q3_5) resistor r=10.0000
    I_Rh1 (XI5_An_5 XI5_An_2) resistor r=1.9400
    I_Rh2 (t67_10 t67_11) resistor r=0.5719
    I_Rh3 (t67_11 t67_3) resistor r=7.192E-02
    I_Rh4 (t67_11 t67_12) resistor r=2.4533
    I_Rh5 (FB FB_6) resistor r=2.0811
    I_Rh6 (FB_5 FB_1) resistor r=0.2160
    I_Rh7 (FB_5 FB_7) resistor r=1.5984
    I_Rh8 (t67_18 t67_15) resistor r=0.1961
    I_Rh9 (t67_15 t67_8) resistor r=3.214E-03
    I_Rh10 (XI1_An_7 XI1_An_4) resistor r=0.3240
    I_Rh11 (XI1_An_4 XI1_An_2) resistor r=0.3240
    I_Rh12 (Q6_8 Q6_9) resistor r=8.392E-02
    I_Rh13 (Q6_9 Q6_5) resistor r=0.2359
    I_Rh14 (Q6_5 Q6_3) resistor r=0.3240
    I_Rh15 (Q6_9 Q6_10) resistor r=1.6519
    I_Rh16 (XI5_p1_4 XI5_p1_2) resistor r=0.4320
    I_Rh17 (Q7_7 Q7_8) resistor r=1.4110
    I_Rh18 (Q7_7 Q7_4) resistor r=0.3240
    I_Rh19 (Q7_4 Q7_2) resistor r=0.3240
    I_Rh20 (wn_8 wn_10) resistor r=1.4599
    I_Rh21 (wn_10 wn_4) resistor r=0.1519
    I_Rh22 (wn_4 wn) resistor r=0.8640
    I_Rh23 (wn_10 wn_11) resistor r=1.5319
    I_Rh24 (XI5_Bn_5 XI5_Bn_2) resistor r=1.9400
    I_Rh25 (Q6 Q6_13) resistor r=1.9397
    I_Rh26 (Q0_12 Q0_11) resistor r=3.4144
    I_Rh27 (t05_3 t05_6) resistor r=0.1669
    I_Rh28 (t05_6 t05_5) resistor r=1.500E-02
    I_Rh29 (Q1 Q1_3) resistor r=2.4540
    I_Rh30 (Q5_9 Q5_5) resistor r=0.3240
    I_Rh31 (Q5_5 Q5_3) resistor r=0.3240
    I_Rh32 (Q5_3 Q5) resistor r=1.2494
    I_Rh33 (Q0_19 Q0_20) resistor r=0.1199
    I_Rh34 (Q0_20 Q0_7) resistor r=0.1999
    I_Rh35 (Q0_7 Q0_3) resistor r=0.2481
    I_Rh36 (Q0_3 Q0_2) resistor r=4.807E-02
    I_Rh37 (Q0_20 Q0) resistor r=0.7986
    I_Rh38 (XI0_An_7 XI0_An_4) resistor r=0.3240
    I_Rh39 (XI0_An_4 XI0_An_2) resistor r=0.3240
    I_Rh40 (Q2 Q2_3) resistor r=2.6476
    I_Rh41 (n012_7 n012_2) resistor r=0.4320
    I_Rh42 (n012_7 n012_8) resistor r=1.5984
    I_Rh43 (n012_4 n012_7) resistor r=1.4000
    I_Rh44 (t05_10 t05_7) resistor r=1.6262
    I_Rh45 (Q6_17 Q6_16) resistor r=1.6177
    I_Rh46 (Q4_3 Q4_4) resistor r=3.0415
    I_Rh47 (n346_11 n346_7) resistor r=2.9019
    I_Rh48 (n346_14 n346_15) resistor r=0.2879
    I_Rh49 (n346_15 n346_2) resistor r=1.5399
    I_Rh50 (n346_15 n346_12) resistor r=0.4319
    I_Rh51 (XI4_p1_3 XI4_p1) resistor r=1.8320
    I_Rh52 (wn_21 wn_22) resistor r=2.0480
    I_Rh53 (wn_22 wn_19) resistor r=0.3234
    I_Rh54 (wn_17 wn_22) resistor r=1.4000
    I_Rh55 (n012_14 n012_10) resistor r=2.2910
    I_Rh56 (Q3_7 Q3_6) resistor r=1.5448
    I_Rg1 (t67_15 t67_12) resistor r=2.0144
    I_Rg2 (FB_8 FB_7) resistor r=1.6415
    I_Rg3 (FB_9 FB_6) resistor r=1.6415
    I_Rg4 (Q7_8 Q7_9) resistor r=1.5019
    I_Rg5 (Q0_3 Q0_4) resistor r=2.9019
    I_Rg6 (Q0_12 Q0_16) resistor r=1.6415
    I_Rg7 (Q6_14 Q6_13) resistor r=2.0144
    I_Rg8 (Q6_13 Q6_10) resistor r=0.6144
    I_Rg9 (wn_14 wn_11) resistor r=2.3872
    I_Rg10 (t05_7 t05_6) resistor r=3.4144
    I_Rg11 (wn_19 wn_20) resistor r=3.0415
    I_Rg12 (Q6_16 Q6_15) resistor r=1.7658
    I_Rg13 (n346_11 n346_12) resistor r=1.9181
    I_Rg14 (Q4_8 Q4_4) resistor r=1.5794
    I_Rg15 (n012_14 n012_8) resistor r=2.3872
    I_Rg16 (Q3 Q3_7) resistor r=0.6642
    I_Rf1 (FB_8 FB_9) resistor r=0.8629
    I_Rf2 (Q7 Q7_9) resistor r=1.2854
    I_Rf3 (Q0_4 Q0_16) resistor r=0.6144
    I_Rf4 (Q6_14 Q6_15) resistor r=3.0086
    I_Rf5 (wn_20 wn_14) resistor r=0.7386
    I_Rf6 (Q4_9 Q4_8) resistor r=1.7658
    I_Re1 (Q4 Q4_9) resistor r=0.9127
    I_C1 (VDD GND) capacitor c=5.664E-15
    I_C2 (FB GND) capacitor c=9.552E-17
    I_C3 (Q0 GND) capacitor c=1.172E-16
    I_C4 (Q1 GND) capacitor c=1.517E-16
    I_C5 (Q2 GND) capacitor c=1.624E-16
    I_C6 (Q3 GND) capacitor c=9.133E-17
    I_C7 (Q4 GND) capacitor c=9.510E-17
    I_C8 (Q5 GND) capacitor c=1.753E-16
    I_C9 (Q6 GND) capacitor c=9.812E-17
    I_C10 (Q7 GND) capacitor c=1.409E-16
    I_C11 (n012 GND) capacitor c=4.237E-17
    I_C12 (n346 GND) capacitor c=2.800E-17
    I_C13 (t05 GND) capacitor c=8.041E-17
    I_C14 (wn GND) capacitor c=3.469E-16
    I_C15 (t67 GND) capacitor c=6.519E-17
    I_C16 (XI5_p1 GND) capacitor c=2.977E-18
    I_C17 (XI5_n2 GND) capacitor c=9.520E-19
    I_C18 (XI5_n1 GND) capacitor c=7.204E-18
    I_C19 (XI5_An GND) capacitor c=9.007E-17
    I_C20 (XI5_Bn GND) capacitor c=1.062E-16
    I_C21 (XI0_An GND) capacitor c=4.137E-17
    I_C22 (XI1_An GND) capacitor c=1.282E-16
    I_C23 (XI3_p2 GND) capacitor c=3.535E-18
    I_C24 (XI3_p1 GND) capacitor c=3.089E-18
    I_C25 (XI2_p2 GND) capacitor c=1.686E-17
    I_C26 (XI2_p1 GND) capacitor c=1.876E-18
    I_C27 (XI4_p1 GND) capacitor c=1.314E-16
    I_C28 (XI4_n1 GND) capacitor c=1.087E-18
    I_C29 (Q3_3 GND) capacitor c=5.041E-17
    I_C30 (n012_12 GND) capacitor c=5.839E-17
    I_C31 (Q4_7 GND) capacitor c=5.173E-17
    I_C32 (n346_8 GND) capacitor c=6.214E-17
    I_C33 (Q6_20 GND) capacitor c=4.532E-17
    I_C34 (t05_11 GND) capacitor c=6.223E-17
    I_C35 (Q2_6 GND) capacitor c=5.312E-17
    I_C36 (Q0_21 GND) capacitor c=6.695E-17
    I_C37 (Q1_6 GND) capacitor c=4.758E-17
    I_C38 (Q0_15 GND) capacitor c=5.771E-17
    I_C39 (Q5_6 GND) capacitor c=6.133E-17
    I_C40 (Q0_5 GND) capacitor c=4.780E-17
    I_C41 (wn_13 GND) capacitor c=4.157E-17
    I_C42 (wn_6 GND) capacitor c=5.352E-17
    I_C43 (Q6_11 GND) capacitor c=4.508E-17
    I_C44 (XI5_Bn_4 GND) capacitor c=5.844E-17
    I_C45 (Q7_5 GND) capacitor c=6.014E-17
    I_C46 (t67_14 GND) capacitor c=6.069E-17
    I_C47 (XI5_An_7 GND) capacitor c=5.882E-17
    I_C48 (Q6_4 GND) capacitor c=5.329E-17
    I_C49 (t67_6 GND) capacitor c=5.979E-17
    I_C50 (Q3_1 GND) capacitor c=5.427E-17
    I_C51 (n012_13 GND) capacitor c=5.420E-17
    I_C52 (Q4_5 GND) capacitor c=5.581E-17
    I_C53 (n346_10 GND) capacitor c=6.057E-17
    I_C54 (Q6_18 GND) capacitor c=5.144E-17
    I_C55 (t05_13 GND) capacitor c=4.927E-17
    I_C56 (Q2_4 GND) capacitor c=5.404E-17
    I_C57 (Q1_4 GND) capacitor c=5.671E-17
    I_C58 (XI0_An_5 GND) capacitor c=3.745E-17
    I_C59 (Q0_13 GND) capacitor c=5.318E-17
    I_C60 (Q5_7 GND) capacitor c=5.519E-17
    I_C61 (Q0_6 GND) capacitor c=5.801E-17
    I_C62 (wn_12 GND) capacitor c=5.231E-17
    I_C63 (Q6_12 GND) capacitor c=5.905E-17
    I_C64 (XI5_Bn_3 GND) capacitor c=5.504E-17
    I_C65 (Q7_6 GND) capacitor c=6.181E-17
    I_C66 (t67_13 GND) capacitor c=5.367E-17
    I_C67 (XI1_An_5 GND) capacitor c=4.117E-17
    I_C68 (XI5_An_6 GND) capacitor c=5.934E-17
    I_C69 (wn_3 GND) capacitor c=5.670E-17
    I_C70 (t67_4 GND) capacitor c=4.269E-17
    I_C71 (n012_14 GND) capacitor c=1.933E-16
    I_C72 (Q3_7 GND) capacitor c=9.935E-17
    I_C73 (n346_11 GND) capacitor c=1.250E-16
    I_C74 (Q4_4 GND) capacitor c=4.958E-17
    I_C75 (n346_12 GND) capacitor c=1.308E-16
    I_C76 (wn_19 GND) capacitor c=1.123E-16
    I_C77 (Q6_16 GND) capacitor c=1.034E-16
    I_C78 (t05_7 GND) capacitor c=1.184E-16
    I_C79 (n012_8 GND) capacitor c=1.991E-16
    I_C80 (t05_6 GND) capacitor c=1.601E-16
    I_C81 (Q0_12 GND) capacitor c=1.190E-16
    I_C82 (Q6_13 GND) capacitor c=2.155E-16
    I_C83 (Q0_3 GND) capacitor c=7.321E-17
    I_C84 (wn_11 GND) capacitor c=1.162E-16
    I_C85 (Q7_8 GND) capacitor c=7.368E-17
    I_C86 (Q6_10 GND) capacitor c=1.363E-16
    I_C87 (FB_7 GND) capacitor c=6.516E-17
    I_C88 (FB_6 GND) capacitor c=1.256E-16
    I_C89 (t67_15 GND) capacitor c=6.236E-17
    I_C90 (t67_12 GND) capacitor c=1.938E-16
    I_C91 (Q3_2 GND) capacitor c=4.756E-17
    I_C92 (n012_9 GND) capacitor c=4.587E-17
    I_C93 (Q4_1 GND) capacitor c=1.421E-16
    I_C94 (n346_5 GND) capacitor c=1.291E-16
    I_C95 (Q6_19 GND) capacitor c=6.279E-17
    I_C96 (t05_8 GND) capacitor c=1.776E-16
    I_C97 (Q2_1 GND) capacitor c=1.584E-16
    I_C98 (Q0_17 GND) capacitor c=5.479E-17
    I_C99 (Q1_1 GND) capacitor c=1.346E-16
    I_C100 (XI0_An_3 GND) capacitor c=1.401E-16
    I_C101 (Q0_9 GND) capacitor c=5.643E-17
    I_C102 (Q5_4 GND) capacitor c=1.253E-16
    I_C103 (Q0_1 GND) capacitor c=1.742E-16
    I_C104 (wn_9 GND) capacitor c=5.487E-17
    I_C105 (wn_5 GND) capacitor c=3.310E-17
    I_C106 (Q6_7 GND) capacitor c=1.786E-16
    I_C107 (Q7_3 GND) capacitor c=1.270E-16
    I_C108 (t67_9 GND) capacitor c=1.061E-16
    I_C109 (XI1_An_3 GND) capacitor c=1.409E-16
    I_C110 (XI5_An_4 GND) capacitor c=9.505E-17
    I_C111 (Q6_1 GND) capacitor c=5.290E-17
    I_C112 (wn_2 GND) capacitor c=4.926E-17
    I_C113 (Q4_9 GND) capacitor c=8.610E-17
    I_C114 (Q4_8 GND) capacitor c=5.556E-17
    I_C115 (wn_20 GND) capacitor c=1.707E-16
    I_C116 (wn_14 GND) capacitor c=2.075E-16
    I_C117 (Q6_14 GND) capacitor c=1.994E-16
    I_C118 (Q6_15 GND) capacitor c=2.740E-16
    I_C119 (Q0_4 GND) capacitor c=8.567E-17
    I_C120 (Q0_16 GND) capacitor c=9.538E-17
    I_C121 (Q7_9 GND) capacitor c=9.481E-17
    I_C122 (FB_8 GND) capacitor c=7.136E-17
    I_C123 (FB_9 GND) capacitor c=1.036E-16
    I_C124 (Q3_6 GND) capacitor c=3.405E-17
    I_C125 (XI4_p1_3 GND) capacitor c=1.176E-16
    I_C126 (wn_21 GND) capacitor c=1.704E-16
    I_C127 (n012_10 GND) capacitor c=2.034E-16
    I_C128 (n346_14 GND) capacitor c=6.397E-17
    I_C129 (Q4_3 GND) capacitor c=2.675E-17
    I_C130 (n346_7 GND) capacitor c=4.424E-17
    I_C131 (Q6_17 GND) capacitor c=5.298E-17
    I_C132 (t05_10 GND) capacitor c=3.923E-17
    I_C133 (n346_2 GND) capacitor c=4.455E-17
    I_C134 (wn_17 GND) capacitor c=1.264E-16
    I_C135 (n012_4 GND) capacitor c=7.372E-17
    I_C136 (XI0_An_7 GND) capacitor c=1.738E-16
    I_C137 (Q2_3 GND) capacitor c=1.804E-16
    I_C138 (Q0_19 GND) capacitor c=1.073E-16
    I_C139 (Q5_9 GND) capacitor c=1.858E-16
    I_C140 (Q1_3 GND) capacitor c=1.266E-16
    I_C141 (XI0_An_4 GND) capacitor c=2.122E-16
    I_C142 (n012_2 GND) capacitor c=1.166E-16
    I_C143 (Q0_7 GND) capacitor c=1.168E-16
    I_C144 (t05_5 GND) capacitor c=1.209E-16
    I_C145 (Q0_11 GND) capacitor c=1.778E-16
    I_C146 (Q5_5 GND) capacitor c=2.174E-16
    I_C147 (t05_3 GND) capacitor c=7.677E-17
    I_C148 (XI0_An_2 GND) capacitor c=1.538E-16
    I_C149 (Q0_2 GND) capacitor c=1.248E-16
    I_C150 (XI5_Bn_5 GND) capacitor c=2.107E-16
    I_C151 (Q5_3 GND) capacitor c=2.438E-16
    I_C152 (wn_8 GND) capacitor c=4.070E-17
    I_C153 (Q7_7 GND) capacitor c=3.275E-17
    I_C154 (wn_4 GND) capacitor c=2.573E-16
    I_C155 (Q6_8 GND) capacitor c=1.293E-16
    I_C156 (XI5_p1_4 GND) capacitor c=1.683E-16
    I_C157 (t67_18 GND) capacitor c=8.237E-17
    I_C158 (XI1_An_7 GND) capacitor c=1.498E-16
    I_C159 (XI5_Bn_2 GND) capacitor c=1.914E-16
    I_C160 (Q7_4 GND) capacitor c=2.399E-16
    I_C161 (FB_5 GND) capacitor c=1.904E-16
    I_C162 (Q6_5 GND) capacitor c=1.255E-16
    I_C163 (t67_8 GND) capacitor c=2.084E-16
    I_C164 (t67_10 GND) capacitor c=2.406E-16
    I_C165 (XI1_An_4 GND) capacitor c=2.023E-16
    I_C166 (FB_1 GND) capacitor c=1.469E-16
    I_C167 (XI5_p1_2 GND) capacitor c=1.524E-16
    I_C168 (Q7_2 GND) capacitor c=1.752E-16
    I_C169 (XI5_An_5 GND) capacitor c=1.707E-16
    I_C170 (Q6_3 GND) capacitor c=1.225E-16
    I_C171 (XI1_An_2 GND) capacitor c=1.806E-16
    I_C172 (t67_3 GND) capacitor c=6.594E-17
    I_C173 (XI5_An_2 GND) capacitor c=1.593E-16
    I_C174 (XI4_p1_2 GND) capacitor c=2.048E-19
    I_C175 (n346_4 GND) capacitor c=8.179E-17
    I_C176 (wn_15 GND) capacitor c=9.457E-17
    I_C177 (n012_6 GND) capacitor c=8.810E-17
    I_C178 (XI0_An_6 GND) capacitor c=1.377E-16
    I_C179 (XI5_Bn_7 GND) capacitor c=9.856E-17
    I_C180 (Q5_1 GND) capacitor c=7.381E-17
    I_C181 (Q7_10 GND) capacitor c=8.239E-17
    I_C182 (t67_16 GND) capacitor c=8.232E-17
    I_C183 (FB_4 GND) capacitor c=1.159E-16
    I_C184 (XI5_An_3 GND) capacitor c=3.679E-17
    I_C185 (wn_23 GND) capacitor c=4.072E-17
    I_C186 (n346_13 GND) capacitor c=3.962E-17
    I_C187 (wn_18 GND) capacitor c=2.418E-17
    I_C188 (n012_3 GND) capacitor c=2.563E-17
    I_C189 (Q5_8 GND) capacitor c=7.385E-17
    I_C190 (t05_4 GND) capacitor c=9.866E-17
    I_C191 (XI5_Bn_6 GND) capacitor c=4.061E-17
    I_C192 (XI1_An_6 GND) capacitor c=4.351E-17
    I_C193 (t67_7 GND) capacitor c=9.972E-17
    I_C194 (FB_3 GND) capacitor c=1.956E-19
    I_C195 (Q7_1 GND) capacitor c=7.384E-17
    I_C196 (Q3_4 GND) capacitor c=5.566E-17
    I_C197 (Q6_21 GND) capacitor c=1.212E-16
    I_C198 (n346_3 GND) capacitor c=1.161E-16
    I_C199 (wn_16 GND) capacitor c=1.170E-16
    I_C200 (n012_5 GND) capacitor c=1.138E-16
    I_C201 (Q0_18 GND) capacitor c=9.782E-17
    I_C202 (t05_2 GND) capacitor c=1.193E-16
    I_C203 (Q5_2 GND) capacitor c=8.115E-17
    I_C204 (wn_7 GND) capacitor c=7.588E-17
    I_C205 (Q7_11 GND) capacitor c=8.921E-17
    I_C206 (t67_17 GND) capacitor c=1.185E-16
    I_C207 (Q6_2 GND) capacitor c=9.997E-17
    I_C208 (t67_2 GND) capacitor c=5.613E-17
    I_C209 (t67_11 GND) capacitor c=1.866E-16
    I_C210 (Q6_9 GND) capacitor c=5.017E-17
    I_C211 (wn_10 GND) capacitor c=3.188E-17
    I_C212 (Q0_20 GND) capacitor c=9.758E-17
    I_C213 (n346_15 GND) capacitor c=9.107E-17
ends CFSR_FB_OPT
