// TSPC_DFF_S sau layout: Assura RCX
simulator lang=spectre
subckt TSPC_DFF_S D CLK SET Q QB VDD GND
    I_M3 (X_3 D_4 GND GND) gpdk090_nmos1v w=0.24u l=0.1u ad=0.0984p as=0.1188p pd=1.3u ps=1.06u
    I_M5 (n4 CLK_8 GND GND) gpdk090_nmos1v w=0.48u l=0.1u ad=0.1392p as=0.1188p pd=1.06u ps=1.06u
    I_M4 (Y X_7 n4 GND) gpdk090_nmos1v w=0.48u l=0.1u ad=0.1968p as=0.1392p pd=1.78u ps=1.06u
    I_MSN (QB_3 SET_4 GND GND) gpdk090_nmos1v w=0.24u l=0.1u ad=0.0984p as=0.0696p pd=1.3u ps=0.82u
    I_M8 (n7 Y_9 GND GND) gpdk090_nmos1v w=0.24u l=0.1u ad=0.0696p as=0.0696p pd=0.82u ps=0.82u
    I_M7 (QB_10 CLK_11 n7 GND) gpdk090_nmos1v w=0.24u l=0.1u ad=0.0984p as=0.0696p pd=1.3u ps=0.82u
    I_MN (Q_6 QB_15 GND GND) gpdk090_nmos1v w=0.24u l=0.1u ad=0.0984p as=0.0984p pd=1.3u ps=1.3u
    I_M2 (X CLK_3 pa VDD) gpdk090_pmos1v w=0.48u l=0.1u ad=0.1968p as=0.1392p pd=1.78u ps=1.06u
    I_M1 (pa D_2 VDD VDD) gpdk090_pmos1v w=0.48u l=0.1u ad=0.1392p as=0.1392p pd=1.06u ps=1.06u
    I_M6 (Y_5 CLK_6 VDD VDD) gpdk090_pmos1v w=0.48u l=0.1u ad=0.1968p as=0.1392p pd=1.78u ps=1.06u
    I_MKY (Y_3 QB_5 VDD VDD) gpdk090_pmos1v w=0.12u l=0.4u ad=0.078p as=0.1086p pd=1.3u ps=1.06u
    I_MSP (ps SET_2 VDD VDD) gpdk090_pmos1v w=0.48u l=0.1u ad=0.1392p as=0.1086p pd=1.06u ps=1.06u
    I_M9 (QB_9 Y_8 ps VDD) gpdk090_pmos1v w=0.48u l=0.1u ad=0.1968p as=0.1392p pd=1.78u ps=1.06u
    I_MKQ (QB_7 Q_3 VDD VDD) gpdk090_pmos1v w=0.12u l=0.4u ad=0.078p as=0.1086p pd=1.3u ps=1.06u
    I_MP (Q_4 QB_14 VDD VDD) gpdk090_pmos1v w=0.48u l=0.1u ad=0.1968p as=0.1086p pd=1.78u ps=1.06u
    I_Rj1 (CLK_3 CLK_2) resistor r=16.5435
    I_Rj2 (D_2 D_3) resistor r=28.5435
    I_Rj3 (D_3 D_4) resistor r=44.5435
    I_Rj4 (D D_3) resistor r=10.0000
    I_Rj5 (CLK_6 CLK_7) resistor r=18.5435
    I_Rj6 (CLK_7 CLK_8) resistor r=42.5435
    I_Rj7 (CLK CLK_7) resistor r=10.0000
    I_Rj8 (X_7 X_5) resistor r=16.5435
    I_Rj9 (QB_1 QB_5) resistor r=52.2934
    I_Rj10 (SET_2 SET_3) resistor r=28.5435
    I_Rj11 (SET_3 SET_4) resistor r=44.5435
    I_Rj12 (SET SET_3) resistor r=10.0000
    I_Rj13 (Y_8 Y_7) resistor r=28.5435
    I_Rj14 (Y_7 Y_9) resistor r=44.5435
    I_Rj15 (CLK_11 CLK_10) resistor r=54.5435
    I_Rj16 (Q_2 Q_3) resistor r=24.2934
    I_Rj17 (QB_14 QB_11) resistor r=44.5435
    I_Rj18 (QB_11 QB_15) resistor r=28.5435
    I_Ri1 (X X_2) resistor r=16.7081
    I_Ri2 (CLK_1 CLK_2) resistor r=11.6192
    I_Ri3 (X_3 X_4) resistor r=16.8414
    I_Ri6 (CLK_4 CLK) resistor r=1.6059
    I_Ri9 (X_5 X_6) resistor r=11.4913
    I_Ri10 (Y Y_2) resistor r=15.7054
    I_Ri11 (Y_2 Y_4) resistor r=3.692E-02
    I_Ri12 (Y_2 Y_5) resistor r=15.3916
    I_Ri13 (Y_3 Y_4) resistor r=15.0000
    I_Ri14 (QB_1 QB_2) resistor r=11.4913
    I_Ri15 (QB_3 QB_4) resistor r=16.8414
    I_Ri18 (Y_6 Y_7) resistor r=11.6592
    I_Ri19 (CLK_9 CLK_10) resistor r=11.6059
    I_Ri20 (QB QB_6) resistor r=0.2814
    I_Ri21 (QB_6 QB_8) resistor r=0.3081
    I_Ri22 (QB_8 QB_9) resistor r=15.4200
    I_Ri23 (QB QB_10) resistor r=15.1600
    I_Ri24 (QB_7 QB_8) resistor r=15.0000
    I_Ri25 (Q_1 Q_2) resistor r=11.6192
    I_Ri26 (QB_11 QB_12) resistor r=11.4913
    I_Ri27 (Q_4 Q_5) resistor r=15.5152
    I_Ri28 (Q_5 Q) resistor r=3.333E-02
    I_Ri29 (Q Q_6) resistor r=15.1600
    I_Rh1 (X_6 X_4) resistor r=0.6800
    I_Rh2 (X_4 X_2) resistor r=0.2720
    I_Rh3 (Y_6 Y_2) resistor r=2.2000
    I_Rh4 (CLK_9 CLK_4) resistor r=1.4800
    I_Rh5 (CLK_4 CLK_1) resistor r=0.5440
    I_Rh6 (QB_12 QB_13) resistor r=0.5280
    I_Rh7 (QB_13 QB_4) resistor r=0.8160
    I_Rh8 (QB_4 QB_2) resistor r=0.1960
    I_Rh9 (QB_6 QB_13) resistor r=1.4000
    I_Rh10 (Q_5 Q_1) resistor r=1.8680
    I_C1 (VDD GND) capacitor c=9.721E-16
    I_C2 (CLK GND) capacitor c=7.762E-17
    I_C3 (D GND) capacitor c=1.461E-16
    I_C4 (Q GND) capacitor c=1.152E-16
    I_C5 (QB GND) capacitor c=5.210E-17
    I_C6 (SET GND) capacitor c=1.383E-16
    I_C7 (ps GND) capacitor c=1.604E-17
    I_C8 (n4 GND) capacitor c=4.664E-18
    I_C9 (Y GND) capacitor c=7.563E-17
    I_C10 (X GND) capacitor c=2.166E-17
    I_C11 (CLK_3 GND) capacitor c=4.394E-17
    I_C12 (D_2 GND) capacitor c=4.675E-17
    I_C13 (CLK_6 GND) capacitor c=4.896E-17
    I_C14 (QB_5 GND) capacitor c=8.188E-17
    I_C15 (SET_2 GND) capacitor c=5.791E-17
    I_C16 (Y_8 GND) capacitor c=3.936E-17
    I_C17 (Q_3 GND) capacitor c=5.400E-17
    I_C18 (QB_14 GND) capacitor c=6.527E-17
    I_C19 (D_4 GND) capacitor c=5.483E-17
    I_C20 (CLK_8 GND) capacitor c=6.025E-17
    I_C21 (X_7 GND) capacitor c=4.406E-17
    I_C22 (SET_4 GND) capacitor c=5.162E-17
    I_C23 (Y_9 GND) capacitor c=5.284E-17
    I_C24 (CLK_11 GND) capacitor c=4.835E-17
    I_C25 (QB_15 GND) capacitor c=5.042E-17
    I_C26 (CLK_2 GND) capacitor c=1.122E-16
    I_C27 (X_5 GND) capacitor c=7.018E-17
    I_C28 (QB_1 GND) capacitor c=6.862E-17
    I_C29 (Y_7 GND) capacitor c=9.580E-17
    I_C30 (CLK_10 GND) capacitor c=1.059E-16
    I_C31 (Q_2 GND) capacitor c=9.384E-17
    I_C32 (QB_11 GND) capacitor c=8.926E-17
    I_C33 (X_2 GND) capacitor c=1.212E-16
    I_C34 (CLK_1 GND) capacitor c=1.695E-16
    I_C35 (X_4 GND) capacitor c=2.553E-16
    I_C36 (CLK_4 GND) capacitor c=2.833E-16
    I_C37 (X_6 GND) capacitor c=1.740E-16
    I_C38 (Y_2 GND) capacitor c=2.404E-16
    I_C39 (QB_2 GND) capacitor c=9.349E-17
    I_C40 (QB_4 GND) capacitor c=2.672E-16
    I_C41 (Y_6 GND) capacitor c=1.736E-16
    I_C42 (CLK_9 GND) capacitor c=2.787E-16
    I_C43 (QB_6 GND) capacitor c=2.363E-16
    I_C44 (Q_1 GND) capacitor c=1.359E-16
    I_C45 (QB_12 GND) capacitor c=1.474E-16
    I_C46 (Q_5 GND) capacitor c=5.915E-17
    I_C47 (Y_5 GND) capacitor c=4.948E-17
    I_C48 (QB_9 GND) capacitor c=6.792E-17
    I_C49 (QB_7 GND) capacitor c=5.188E-17
    I_C50 (Q_4 GND) capacitor c=4.322E-17
    I_C51 (X_3 GND) capacitor c=5.563E-17
    I_C52 (QB_3 GND) capacitor c=4.906E-17
    I_C53 (QB_10 GND) capacitor c=2.391E-17
    I_C54 (Q_6 GND) capacitor c=2.148E-17
ends TSPC_DFF_S
