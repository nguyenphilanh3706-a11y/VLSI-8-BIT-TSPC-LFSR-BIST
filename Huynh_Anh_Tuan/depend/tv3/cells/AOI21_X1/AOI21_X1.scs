// AOI21_X1.  Y = !(A1 & A2 | B)
// Pins: A1 A2 B Y VDD GND.  6 transistors: N A1-A2 noi tiep song song voi B; P (A1 || A2) noi tiep B.
simulator lang=spectre
subckt AOI21_X1 A1 A2 B Y VDD GND
    MN0 (Y A1 n1 GND) gpdk090_nmos1v w=0.24u l=0.1u
    MN1 (n1 A2 GND GND) gpdk090_nmos1v w=0.24u l=0.1u
    MN2 (Y B GND GND) gpdk090_nmos1v w=0.12u l=0.1u
    MP0 (p1 A1 VDD VDD) gpdk090_pmos1v w=0.48u l=0.1u
    MP1 (p1 A2 VDD VDD) gpdk090_pmos1v w=0.48u l=0.1u
    MP2 (Y B p1 VDD) gpdk090_pmos1v w=0.48u l=0.1u
ends AOI21_X1
