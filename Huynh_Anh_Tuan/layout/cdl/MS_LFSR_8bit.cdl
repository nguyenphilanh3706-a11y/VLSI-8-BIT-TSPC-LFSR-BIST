.SUBCKT DFF_MS_TMP D CLK CLKB SET RST Q VDD GND
MMN1 n1 CLKB D GND nmos1v w=0.24u l=0.1u
MMP1 n1 CLK D VDD pmos1v w=0.48u l=0.1u
MI1_MN0 mb n1 GND GND nmos1v w=0.12u l=0.1u
MI1_MN1 mb SET GND GND nmos1v w=0.12u l=0.1u
MI1_MP0 I1_p1 n1 VDD VDD pmos1v w=0.48u l=0.1u
MI1_MP1 mb SET I1_p1 VDD pmos1v w=0.48u l=0.1u
MI2_MN0 n1f mb GND GND nmos1v w=0.12u l=0.1u
MI2_MN1 n1f RST GND GND nmos1v w=0.12u l=0.1u
MI2_MP0 I2_p1 mb VDD VDD pmos1v w=0.48u l=0.1u
MI2_MP1 n1f RST I2_p1 VDD pmos1v w=0.48u l=0.1u
MMN2 n1 CLK n1f GND nmos1v w=0.24u l=0.1u
MMP2 n1 CLKB n1f VDD pmos1v w=0.48u l=0.1u
MMN3 n2 CLK mb GND nmos1v w=0.24u l=0.1u
MMP3 n2 CLKB mb VDD pmos1v w=0.48u l=0.1u
MI3_MN0 Q n2 GND GND nmos1v w=0.12u l=0.1u
MI3_MN1 Q RST GND GND nmos1v w=0.12u l=0.1u
MI3_MP0 I3_p1 n2 VDD VDD pmos1v w=0.48u l=0.1u
MI3_MP1 Q RST I3_p1 VDD pmos1v w=0.48u l=0.1u
MI4_MN0 n2f Q GND GND nmos1v w=0.12u l=0.1u
MI4_MN1 n2f SET GND GND nmos1v w=0.12u l=0.1u
MI4_MP0 I4_p1 Q VDD VDD pmos1v w=0.48u l=0.1u
MI4_MP1 n2f SET I4_p1 VDD pmos1v w=0.48u l=0.1u
MMN4 n2 CLKB n2f GND nmos1v w=0.24u l=0.1u
MMP4 n2 CLK n2f VDD pmos1v w=0.48u l=0.1u
.ENDS

.SUBCKT XOR2_TG6 A B Y VDD GND
MMN0 An A GND GND nmos1v w=0.12u l=0.1u
MMP0 An A VDD VDD pmos1v w=0.24u l=0.1u
MMN1 Y B An GND nmos1v w=0.24u l=0.1u
MMP1 Y B A VDD pmos1v w=0.48u l=0.1u
MMN2 Y An B GND nmos1v w=0.12u l=0.1u
MMP2 Y A B VDD pmos1v w=0.24u l=0.1u
.ENDS

.SUBCKT XOR2_X1 A B Y VDD GND
MMN0 An A GND GND nmos1v w=0.12u l=0.1u
MMP0 An A VDD VDD pmos1v w=0.24u l=0.1u
MMN1 Bn B GND GND nmos1v w=0.12u l=0.1u
MMP1 Bn B VDD VDD pmos1v w=0.24u l=0.1u
MMN2 Y A n1 GND nmos1v w=0.24u l=0.1u
MMN3 n1 B GND GND nmos1v w=0.24u l=0.1u
MMN4 Y An n2 GND nmos1v w=0.24u l=0.1u
MMN5 n2 Bn GND GND nmos1v w=0.24u l=0.1u
MMP2 p1 A VDD VDD pmos1v w=0.48u l=0.1u
MMP3 p1 B VDD VDD pmos1v w=0.48u l=0.1u
MMP4 Y An p1 VDD pmos1v w=0.48u l=0.1u
MMP5 Y Bn p1 VDD pmos1v w=0.48u l=0.1u
.ENDS

.SUBCKT INV_CLK A Y VDD GND
MMN0 Y A GND GND nmos1v w=0.48u l=0.1u
MMP0 Y A VDD VDD pmos1v w=0.96u l=0.1u
.ENDS

.SUBCKT MS_LFSR_8bit CLK RST Q0 Q1 Q2 Q3 Q4 Q5 Q6 Q7 VDD GND
XCK CLK CLKB VDD GND INV_CLK
XF0 D0 CLK CLKB RST GND Q0 VDD GND DFF_MS_TMP
XF1 Q0 CLK CLKB GND RST Q1 VDD GND DFF_MS_TMP
XF2 Q1 CLK CLKB GND RST Q2 VDD GND DFF_MS_TMP
XF3 Q2 CLK CLKB GND RST Q3 VDD GND DFF_MS_TMP
XF4 Q3 CLK CLKB GND RST Q4 VDD GND DFF_MS_TMP
XF5 Q4 CLK CLKB GND RST Q5 VDD GND DFF_MS_TMP
XF6 Q5 CLK CLKB GND RST Q6 VDD GND DFF_MS_TMP
XF7 Q6 CLK CLKB GND RST Q7 VDD GND DFF_MS_TMP
XX0 Q0 Q5 t05 VDD GND XOR2_TG6
XX1 Q6 Q7 t67 VDD GND XOR2_TG6
XX2 t05 t67 D0 VDD GND XOR2_X1
.ENDS
