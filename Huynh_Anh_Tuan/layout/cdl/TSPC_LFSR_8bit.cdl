.SUBCKT TSPC_DFF_S D CLK SET Q QB VDD GND
M1 pa D VDD VDD pmos1v w=480e-9 l=100e-9
M2 X CLK pa VDD pmos1v w=480e-9 l=100e-9
M3 X D GND GND nmos1v w=240e-9 l=100e-9
M6 Y CLK VDD VDD pmos1v w=480e-9 l=100e-9
M4 Y X n4 GND nmos1v w=480e-9 l=100e-9
M5 n4 CLK GND GND nmos1v w=480e-9 l=100e-9
MSP ps SET VDD VDD pmos1v w=480e-9 l=100e-9
M9 QB Y ps VDD pmos1v w=480e-9 l=100e-9
M7 QB CLK n7 GND nmos1v w=240e-9 l=100e-9
M8 n7 Y GND GND nmos1v w=240e-9 l=100e-9
MSN QB SET GND GND nmos1v w=240e-9 l=100e-9
MP Q QB VDD VDD pmos1v w=480e-9 l=100e-9
MN Q QB GND GND nmos1v w=240e-9 l=100e-9
MKQ QB Q VDD VDD pmos1v w=120e-9 l=400e-9
MKY Y QB VDD VDD pmos1v w=120e-9 l=400e-9
.ENDS
.SUBCKT TSPC_DFF_R D CLK RST Q QB VDD GND
M1 pa D VDD VDD pmos1v w=480e-9 l=100e-9
M2 X CLK pa VDD pmos1v w=480e-9 l=100e-9
M3 X D GND GND nmos1v w=240e-9 l=100e-9
MRP pm RST VDD VDD pmos1v w=480e-9 l=100e-9
M6 Y CLK pm VDD pmos1v w=480e-9 l=100e-9
M4 Y X n4 GND nmos1v w=480e-9 l=100e-9
M5 n4 CLK GND GND nmos1v w=480e-9 l=100e-9
MRN Y RST GND GND nmos1v w=240e-9 l=100e-9
M9 QB Y VDD VDD pmos1v w=480e-9 l=100e-9
M7 QB CLK n7 GND nmos1v w=240e-9 l=100e-9
M8 n7 Y GND GND nmos1v w=240e-9 l=100e-9
MP Q QB VDD VDD pmos1v w=480e-9 l=100e-9
MN Q QB GND GND nmos1v w=240e-9 l=100e-9
MKQ QB Q VDD VDD pmos1v w=120e-9 l=400e-9
MKY Y QB VDD VDD pmos1v w=120e-9 l=400e-9
.ENDS
.SUBCKT XOR2_TG6 A B Y VDD GND
MMN0 An A GND GND nmos1v w=0.12u l=0.1u
MMP0 An A VDD VDD pmos1v w=0.24u l=0.1u
MMN1 Y B An GND nmos1v w=0.24u l=0.1u
MMP1 Y B A VDD pmos1v w=0.48u l=0.1u
MMN2 Y An B GND nmos1v w=0.12u l=0.1u
MMP2 Y A B VDD pmos1v w=0.24u l=0.1u
.ENDS

.SUBCKT XOR2_X1 A B Y VDD GND
MMN0 An A GND GND nmos1v w=0.12u l=0.1u
MMP0 An A VDD VDD pmos1v w=0.24u l=0.1u
MMN1 Bn B GND GND nmos1v w=0.12u l=0.1u
MMP1 Bn B VDD VDD pmos1v w=0.24u l=0.1u
MMN2 Y A n1 GND nmos1v w=0.24u l=0.1u
MMN3 n1 B GND GND nmos1v w=0.24u l=0.1u
MMN4 Y An n2 GND nmos1v w=0.24u l=0.1u
MMN5 n2 Bn GND GND nmos1v w=0.24u l=0.1u
MMP2 p1 A VDD VDD pmos1v w=0.48u l=0.1u
MMP3 p1 B VDD VDD pmos1v w=0.48u l=0.1u
MMP4 Y An p1 VDD pmos1v w=0.48u l=0.1u
MMP5 Y Bn p1 VDD pmos1v w=0.48u l=0.1u
.ENDS

.SUBCKT TSPC_LFSR_8bit CLK RST Q0 Q1 Q2 Q3 Q4 Q5 Q6 Q7 VDD GND
XF0 D0 CLK RST Q0 qb0 VDD GND TSPC_DFF_S
XF1 Q0 CLK RST Q1 qb1 VDD GND TSPC_DFF_R
XF2 Q1 CLK RST Q2 qb2 VDD GND TSPC_DFF_R
XF3 Q2 CLK RST Q3 qb3 VDD GND TSPC_DFF_R
XF4 Q3 CLK RST Q4 qb4 VDD GND TSPC_DFF_R
XF5 Q4 CLK RST Q5 qb5 VDD GND TSPC_DFF_R
XF6 Q5 CLK RST Q6 qb6 VDD GND TSPC_DFF_R
XF7 Q6 CLK RST Q7 qb7 VDD GND TSPC_DFF_R
XX0 Q0 Q5 t05 VDD GND XOR2_TG6
XX1 Q6 Q7 t67 VDD GND XOR2_TG6
XX2 t05 t67 D0 VDD GND XOR2_X1
.ENDS
