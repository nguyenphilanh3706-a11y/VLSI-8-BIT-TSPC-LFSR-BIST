.SUBCKT DFF_TSPC_TMP D CLK SET RST Q VDD GND
MMP1 p1 D VDD VDD pmos1v w=0.48u l=0.1u
MMP2 X CLK p1 VDD pmos1v w=0.48u l=0.1u
MMN1 X D GND GND nmos1v w=0.12u l=0.1u
MMP3 Y CLK VDD VDD pmos1v w=0.48u l=0.1u
MMN2 Y X n1 GND nmos1v w=0.36u l=0.1u
MMN3 n1 CLK GND GND nmos1v w=0.36u l=0.1u
MMPS p2 SET VDD VDD pmos1v w=0.48u l=0.1u
MMP4 QB Y p2 VDD pmos1v w=0.48u l=0.1u
MMN4 QB CLK n2 GND nmos1v w=0.36u l=0.1u
MMN5 n2 Y n3 GND nmos1v w=0.36u l=0.1u
MMNR n3 RSTB GND GND nmos1v w=0.36u l=0.1u
MMNS QB SET GND GND nmos1v w=0.24u l=0.1u
MMPR QB RSTB VDD VDD pmos1v w=0.24u l=0.1u
MMN6 RSTB RST GND GND nmos1v w=0.12u l=0.1u
MMP6 RSTB RST VDD VDD pmos1v w=0.24u l=0.1u
MMN7 Q QB GND GND nmos1v w=0.24u l=0.1u
MMP7 Q QB VDD VDD pmos1v w=0.48u l=0.1u
.ENDS

.SUBCKT XOR2_TG6 A B Y VDD GND
MMN0 An A GND GND nmos1v w=0.12u l=0.1u
MMP0 An A VDD VDD pmos1v w=0.24u l=0.1u
MMN1 Y B An GND nmos1v w=0.24u l=0.1u
MMP1 Y B A VDD pmos1v w=0.48u l=0.1u
MMN2 Y An B GND nmos1v w=0.12u l=0.1u
MMP2 Y A B VDD pmos1v w=0.24u l=0.1u
.ENDS

.SUBCKT XOR2_X1 A B Y VDD GND
MMN0 An A GND GND nmos1v w=0.12u l=0.1u
MMP0 An A VDD VDD pmos1v w=0.24u l=0.1u
MMN1 Bn B GND GND nmos1v w=0.12u l=0.1u
MMP1 Bn B VDD VDD pmos1v w=0.24u l=0.1u
MMN2 Y A n1 GND nmos1v w=0.24u l=0.1u
MMN3 n1 B GND GND nmos1v w=0.24u l=0.1u
MMN4 Y An n2 GND nmos1v w=0.24u l=0.1u
MMN5 n2 Bn GND GND nmos1v w=0.24u l=0.1u
MMP2 p1 A VDD VDD pmos1v w=0.48u l=0.1u
MMP3 p1 B VDD VDD pmos1v w=0.48u l=0.1u
MMP4 Y An p1 VDD pmos1v w=0.48u l=0.1u
MMP5 Y Bn p1 VDD pmos1v w=0.48u l=0.1u
.ENDS

.SUBCKT TSPC_LFSR_8bit CLK RST Q0 Q1 Q2 Q3 Q4 Q5 Q6 Q7 VDD GND
XF0 D0 CLK RST GND Q0 VDD GND DFF_TSPC_TMP
XF1 Q0 CLK GND RST Q1 VDD GND DFF_TSPC_TMP
XF2 Q1 CLK GND RST Q2 VDD GND DFF_TSPC_TMP
XF3 Q2 CLK GND RST Q3 VDD GND DFF_TSPC_TMP
XF4 Q3 CLK GND RST Q4 VDD GND DFF_TSPC_TMP
XF5 Q4 CLK GND RST Q5 VDD GND DFF_TSPC_TMP
XF6 Q5 CLK GND RST Q6 VDD GND DFF_TSPC_TMP
XF7 Q6 CLK GND RST Q7 VDD GND DFF_TSPC_TMP
XX0 Q0 Q5 t05 VDD GND XOR2_TG6
XX1 Q6 Q7 t67 VDD GND XOR2_TG6
XX2 t05 t67 D0 VDD GND XOR2_X1
.ENDS
