// MS_LFSR_8bit sau layout: Assura RCX (R + C), sinh boi scripts/layout/rcx2scs.py
simulator lang=spice
.SUBCKT MS_LFSR_8bit_RCX VDD GND CLK Q0 Q1 Q2 Q3 Q4 Q5 Q6 Q7 RST
MavI12/avD1_1	avI12/avC11	CLK_h113	avI12/avC9_h9	GND_h119
+ gpdk090_nmos1v	L=0.1U	W=0.24U
+ AD=0.0528P	AS=0.0468P	PD=0.68U	PS=0.68U
MavI12/avD1_2	avI12/avC13	avC13_h111	avI12/avC11	GND_h119
+ gpdk090_nmos1v	L=0.1U	W=0.24U
+ AD=0.0816P	AS=0.0528P	PD=1.16U	PS=0.68U
MavI12/avD1_3	GND_h145	GND_h116	avI12/avC13_h5	GND_h119
+ gpdk090_nmos1v	L=0.1U	W=0.12U
+ AD=0.0408P	AS=0.0696P	PD=0.68U	PS=1.16U
MavI12/avD1_4	avI12/avC13_h8	Q7_h8	GND_h145	GND_h119 gpdk090_nmos1v
+ L=0.1U	W=0.12U
+ AD=0.0696P	AS=0.0408P	PD=1.16U	PS=0.68U
MavI12/avD1_5	GND_h144	avI12/avC11_h8	Q7_h3	GND_h119 gpdk090_nmos1v
+ L=0.1U	W=0.12U
+ AD=0.0408P	AS=0.0696P	PD=0.68U	PS=1.16U
MavI12/avD1_6	Q7_h11	RST_h96	GND_h144	GND_h119 gpdk090_nmos1v	L=0.1U
+ W=0.12U
+ AD=0.0696P	AS=0.0408P	PD=1.16U	PS=0.68U
MavI12/avD1_7	avI12/avC10	avC13_h101	Q6_h13	GND_h119 gpdk090_nmos1v
+ L=0.1U	W=0.24U
+ AD=0.0528P	AS=0.0816P	PD=0.68U	PS=1.16U
MavI12/avD1_8	avI12/avC12	CLK_h107	avI12/avC10	GND_h119
+ gpdk090_nmos1v	L=0.1U	W=0.24U
+ AD=0.0816P	AS=0.0528P	PD=1.16U	PS=0.68U
MavI12/avD1_9	GND_h147	RST_h90	avI12/avC12_h5	GND_h119 gpdk090_nmos1v
+ L=0.1U	W=0.12U
+ AD=0.0408P	AS=0.0696P	PD=0.68U	PS=1.16U
MavI12/avD1_10	avI12/avC12_h8	avI12/avC9_h6	GND_h147	GND_h119
+ gpdk090_nmos1v	L=0.1U	W=0.12U
+ AD=0.0696P	AS=0.0408P	PD=1.16U	PS=0.68U
MavI12/avD1_11	GND_h146	avI12/avC10_h8	avI12/avC9_h3	GND_h119
+ gpdk090_nmos1v	L=0.1U	W=0.12U
+ AD=0.0408P	AS=0.0696P	PD=0.68U	PS=1.16U
MavI12/avD1_12	avI12/avC9_h9	GND_h108	GND_h146	GND_h119
+ gpdk090_nmos1v	L=0.1U	W=0.12U
+ AD=0.0468P	AS=0.0408P	PD=0.68U	PS=0.68U
MavI11/avD1_1	avI11/avC11	CLK_h100	avI11/avC9_h9	GND_h119
+ gpdk090_nmos1v	L=0.1U	W=0.24U
+ AD=0.0528P	AS=0.0468P	PD=0.68U	PS=0.68U
MavI11/avD1_2	avI11/avC13	avC13_h98	avI11/avC11	GND_h119
+ gpdk090_nmos1v	L=0.1U	W=0.24U
+ AD=0.0816P	AS=0.0528P	PD=1.16U	PS=0.68U
MavI11/avD1_3	GND_h149	GND_h101	avI11/avC13_h5	GND_h119
+ gpdk090_nmos1v	L=0.1U	W=0.12U
+ AD=0.0408P	AS=0.0696P	PD=0.68U	PS=1.16U
MavI11/avD1_4	avI11/avC13_h8	Q6_h8	GND_h149	GND_h119 gpdk090_nmos1v
+ L=0.1U	W=0.12U
+ AD=0.0696P	AS=0.0408P	PD=1.16U	PS=0.68U
MavI11/avD1_5	GND_h148	avI11/avC11_h8	Q6_h3	GND_h119 gpdk090_nmos1v
+ L=0.1U	W=0.12U
+ AD=0.0408P	AS=0.0696P	PD=0.68U	PS=1.16U
MavI11/avD1_6	Q6_h11	RST_h84	GND_h148	GND_h119 gpdk090_nmos1v	L=0.1U
+ W=0.12U
+ AD=0.0696P	AS=0.0408P	PD=1.16U	PS=0.68U
MavI11/avD1_7	avI11/avC10	avC13_h88	Q5_h14	GND_h119 gpdk090_nmos1v
+ L=0.1U	W=0.24U
+ AD=0.0528P	AS=0.0816P	PD=0.68U	PS=1.16U
MavI11/avD1_8	avI11/avC12	CLK_h94	avI11/avC10	GND_h119 gpdk090_nmos1v
+ L=0.1U	W=0.24U
+ AD=0.0816P	AS=0.0528P	PD=1.16U	PS=0.68U
MavI11/avD1_9	GND_h151	RST_h78	avI11/avC12_h5	GND_h119 gpdk090_nmos1v
+ L=0.1U	W=0.12U
+ AD=0.0408P	AS=0.0696P	PD=0.68U	PS=1.16U
MavI11/avD1_10	avI11/avC12_h8	avI11/avC9_h6	GND_h151	GND_h119
+ gpdk090_nmos1v	L=0.1U	W=0.12U
+ AD=0.0696P	AS=0.0408P	PD=1.16U	PS=0.68U
MavI11/avD1_11	GND_h150	avI11/avC10_h8	avI11/avC9_h3	GND_h119
+ gpdk090_nmos1v	L=0.1U	W=0.12U
+ AD=0.0408P	AS=0.0696P	PD=0.68U	PS=1.16U
MavI11/avD1_12	avI11/avC9_h9	GND_h93	GND_h150	GND_h119 gpdk090_nmos1v
+ L=0.1U	W=0.12U
+ AD=0.0468P	AS=0.0408P	PD=0.68U	PS=0.68U
MavI10/avD1_1	avI10/avC11	CLK_h87	avI10/avC9_h9	GND_h119 gpdk090_nmos1v
+ L=0.1U	W=0.24U
+ AD=0.0528P	AS=0.0468P	PD=0.68U	PS=0.68U
MavI10/avD1_2	avI10/avC13	avC13_h85	avI10/avC11	GND_h119
+ gpdk090_nmos1v	L=0.1U	W=0.24U
+ AD=0.0816P	AS=0.0528P	PD=1.16U	PS=0.68U
MavI10/avD1_3	GND_h153	GND_h86	avI10/avC13_h5	GND_h119 gpdk090_nmos1v
+ L=0.1U	W=0.12U
+ AD=0.0408P	AS=0.0696P	PD=0.68U	PS=1.16U
MavI10/avD1_4	avI10/avC13_h8	Q5_h8	GND_h153	GND_h119 gpdk090_nmos1v
+ L=0.1U	W=0.12U
+ AD=0.0696P	AS=0.0408P	PD=1.16U	PS=0.68U
MavI10/avD1_5	GND_h152	avI10/avC11_h8	Q5_h3	GND_h119 gpdk090_nmos1v
+ L=0.1U	W=0.12U
+ AD=0.0408P	AS=0.0696P	PD=0.68U	PS=1.16U
MavI10/avD1_6	Q5_h11	RST_h72	GND_h152	GND_h119 gpdk090_nmos1v	L=0.1U
+ W=0.12U
+ AD=0.0696P	AS=0.0408P	PD=1.16U	PS=0.68U
MavI10/avD1_7	avI10/avC10	avC13_h75	Q4_h14	GND_h119 gpdk090_nmos1v
+ L=0.1U	W=0.24U
+ AD=0.0528P	AS=0.0816P	PD=0.68U	PS=1.16U
MavI10/avD1_8	avI10/avC12	CLK_h81	avI10/avC10	GND_h119 gpdk090_nmos1v
+ L=0.1U	W=0.24U
+ AD=0.0816P	AS=0.0528P	PD=1.16U	PS=0.68U
MavI10/avD1_9	GND_h155	RST_h66	avI10/avC12_h5	GND_h119 gpdk090_nmos1v
+ L=0.1U	W=0.12U
+ AD=0.0408P	AS=0.0696P	PD=0.68U	PS=1.16U
MavI10/avD1_10	avI10/avC12_h8	avI10/avC9_h6	GND_h155	GND_h119
+ gpdk090_nmos1v	L=0.1U	W=0.12U
+ AD=0.0696P	AS=0.0408P	PD=1.16U	PS=0.68U
MavI10/avD1_11	GND_h154	avI10/avC10_h8	avI10/avC9_h3	GND_h119
+ gpdk090_nmos1v	L=0.1U	W=0.12U
+ AD=0.0408P	AS=0.0696P	PD=0.68U	PS=1.16U
MavI10/avD1_12	avI10/avC9_h9	GND_h78	GND_h154	GND_h119 gpdk090_nmos1v
+ L=0.1U	W=0.12U
+ AD=0.0468P	AS=0.0408P	PD=0.68U	PS=0.68U
MavI9/avD1_1	avI9/avC11	CLK_h74	avI9/avC9_h9	GND_h119 gpdk090_nmos1v
+ L=0.1U	W=0.24U
+ AD=0.0528P	AS=0.0468P	PD=0.68U	PS=0.68U
MavI9/avD1_2	avI9/avC13	avC13_h72	avI9/avC11	GND_h119
+ gpdk090_nmos1v	L=0.1U	W=0.24U
+ AD=0.0816P	AS=0.0528P	PD=1.16U	PS=0.68U
MavI9/avD1_3	GND_h157	GND_h71	avI9/avC13_h5	GND_h119 gpdk090_nmos1v
+ L=0.1U	W=0.12U
+ AD=0.0408P	AS=0.0696P	PD=0.68U	PS=1.16U
MavI9/avD1_4	avI9/avC13_h8	Q4_h8	GND_h157	GND_h119 gpdk090_nmos1v
+ L=0.1U	W=0.12U
+ AD=0.0696P	AS=0.0408P	PD=1.16U	PS=0.68U
MavI9/avD1_5	GND_h156	avI9/avC11_h8	Q4_h3	GND_h119 gpdk090_nmos1v
+ L=0.1U	W=0.12U
+ AD=0.0408P	AS=0.0696P	PD=0.68U	PS=1.16U
MavI9/avD1_6	Q4_h11	RST_h60	GND_h156	GND_h119 gpdk090_nmos1v	L=0.1U
+ W=0.12U
+ AD=0.0696P	AS=0.0408P	PD=1.16U	PS=0.68U
MavI9/avD1_7	avI9/avC10	avC13_h62	Q3_h14	GND_h119 gpdk090_nmos1v
+ L=0.1U	W=0.24U
+ AD=0.0528P	AS=0.0816P	PD=0.68U	PS=1.16U
MavI9/avD1_8	avI9/avC12	CLK_h68	avI9/avC10	GND_h119 gpdk090_nmos1v
+ L=0.1U	W=0.24U
+ AD=0.0816P	AS=0.0528P	PD=1.16U	PS=0.68U
MavI9/avD1_9	GND_h159	RST_h54	avI9/avC12_h5	GND_h119 gpdk090_nmos1v
+ L=0.1U	W=0.12U
+ AD=0.0408P	AS=0.0696P	PD=0.68U	PS=1.16U
MavI9/avD1_10	avI9/avC12_h8	avI9/avC9_h6	GND_h159	GND_h119
+ gpdk090_nmos1v	L=0.1U	W=0.12U
+ AD=0.0696P	AS=0.0408P	PD=1.16U	PS=0.68U
MavI9/avD1_11	GND_h158	avI9/avC10_h8	avI9/avC9_h3	GND_h119
+ gpdk090_nmos1v	L=0.1U	W=0.12U
+ AD=0.0408P	AS=0.0696P	PD=0.68U	PS=1.16U
MavI9/avD1_12	avI9/avC9_h9	GND_h63	GND_h158	GND_h119 gpdk090_nmos1v
+ L=0.1U	W=0.12U
+ AD=0.0468P	AS=0.0408P	PD=0.68U	PS=0.68U
MavI8/avD1_1	avI8/avC11	CLK_h61	avI8/avC9_h9	GND_h119 gpdk090_nmos1v
+ L=0.1U	W=0.24U
+ AD=0.0528P	AS=0.0468P	PD=0.68U	PS=0.68U
MavI8/avD1_2	avI8/avC13	avC13_h59	avI8/avC11	GND_h119
+ gpdk090_nmos1v	L=0.1U	W=0.24U
+ AD=0.0816P	AS=0.0528P	PD=1.16U	PS=0.68U
MavI8/avD1_3	GND_h161	GND_h56	avI8/avC13_h5	GND_h119 gpdk090_nmos1v
+ L=0.1U	W=0.12U
+ AD=0.0408P	AS=0.0696P	PD=0.68U	PS=1.16U
MavI8/avD1_4	avI8/avC13_h8	Q3_h8	GND_h161	GND_h119 gpdk090_nmos1v
+ L=0.1U	W=0.12U
+ AD=0.0696P	AS=0.0408P	PD=1.16U	PS=0.68U
MavI8/avD1_5	GND_h160	avI8/avC11_h8	Q3_h3	GND_h119 gpdk090_nmos1v
+ L=0.1U	W=0.12U
+ AD=0.0408P	AS=0.0696P	PD=0.68U	PS=1.16U
MavI8/avD1_6	Q3_h11	RST_h48	GND_h160	GND_h119 gpdk090_nmos1v	L=0.1U
+ W=0.12U
+ AD=0.0696P	AS=0.0408P	PD=1.16U	PS=0.68U
MavI8/avD1_7	avI8/avC10	avC13_h49	Q2_h14	GND_h119 gpdk090_nmos1v
+ L=0.1U	W=0.24U
+ AD=0.0528P	AS=0.0816P	PD=0.68U	PS=1.16U
MavI8/avD1_8	avI8/avC12	CLK_h55	avI8/avC10	GND_h119 gpdk090_nmos1v
+ L=0.1U	W=0.24U
+ AD=0.0816P	AS=0.0528P	PD=1.16U	PS=0.68U
MavI8/avD1_9	GND_h163	RST_h42	avI8/avC12_h5	GND_h119 gpdk090_nmos1v
+ L=0.1U	W=0.12U
+ AD=0.0408P	AS=0.0696P	PD=0.68U	PS=1.16U
MavI8/avD1_10	avI8/avC12_h8	avI8/avC9_h6	GND_h163	GND_h119
+ gpdk090_nmos1v	L=0.1U	W=0.12U
+ AD=0.0696P	AS=0.0408P	PD=1.16U	PS=0.68U
MavI8/avD1_11	GND_h162	avI8/avC10_h8	avI8/avC9_h3	GND_h119
+ gpdk090_nmos1v	L=0.1U	W=0.12U
+ AD=0.0408P	AS=0.0696P	PD=0.68U	PS=1.16U
MavI8/avD1_12	avI8/avC9_h9	GND_h48	GND_h162	GND_h119 gpdk090_nmos1v
+ L=0.1U	W=0.12U
+ AD=0.0468P	AS=0.0408P	PD=0.68U	PS=0.68U
MavI7/avD1_1	avI7/avC11	CLK_h48	avI7/avC9_h9	GND_h119 gpdk090_nmos1v
+ L=0.1U	W=0.24U
+ AD=0.0528P	AS=0.0468P	PD=0.68U	PS=0.68U
MavI7/avD1_2	avI7/avC13	avC13_h46	avI7/avC11	GND_h119
+ gpdk090_nmos1v	L=0.1U	W=0.24U
+ AD=0.0816P	AS=0.0528P	PD=1.16U	PS=0.68U
MavI7/avD1_3	GND_h165	GND_h41	avI7/avC13_h5	GND_h119 gpdk090_nmos1v
+ L=0.1U	W=0.12U
+ AD=0.0408P	AS=0.0696P	PD=0.68U	PS=1.16U
MavI7/avD1_4	avI7/avC13_h8	Q2_h8	GND_h165	GND_h119 gpdk090_nmos1v
+ L=0.1U	W=0.12U
+ AD=0.0696P	AS=0.0408P	PD=1.16U	PS=0.68U
MavI7/avD1_5	GND_h164	avI7/avC11_h8	Q2_h3	GND_h119 gpdk090_nmos1v
+ L=0.1U	W=0.12U
+ AD=0.0408P	AS=0.0696P	PD=0.68U	PS=1.16U
MavI7/avD1_6	Q2_h11	RST_h36	GND_h164	GND_h119 gpdk090_nmos1v	L=0.1U
+ W=0.12U
+ AD=0.0696P	AS=0.0408P	PD=1.16U	PS=0.68U
MavI7/avD1_7	avI7/avC10	avC13_h36	Q1_h14	GND_h119 gpdk090_nmos1v
+ L=0.1U	W=0.24U
+ AD=0.0528P	AS=0.0816P	PD=0.68U	PS=1.16U
MavI7/avD1_8	avI7/avC12	CLK_h42	avI7/avC10	GND_h119 gpdk090_nmos1v
+ L=0.1U	W=0.24U
+ AD=0.0816P	AS=0.0528P	PD=1.16U	PS=0.68U
MavI7/avD1_9	GND_h167	RST_h30	avI7/avC12_h5	GND_h119 gpdk090_nmos1v
+ L=0.1U	W=0.12U
+ AD=0.0408P	AS=0.0696P	PD=0.68U	PS=1.16U
MavI7/avD1_10	avI7/avC12_h8	avI7/avC9_h6	GND_h167	GND_h119
+ gpdk090_nmos1v	L=0.1U	W=0.12U
+ AD=0.0696P	AS=0.0408P	PD=1.16U	PS=0.68U
MavI7/avD1_11	GND_h166	avI7/avC10_h8	avI7/avC9_h3	GND_h119
+ gpdk090_nmos1v	L=0.1U	W=0.12U
+ AD=0.0408P	AS=0.0696P	PD=0.68U	PS=1.16U
MavI7/avD1_12	avI7/avC9_h9	GND_h33	GND_h166	GND_h119 gpdk090_nmos1v
+ L=0.1U	W=0.12U
+ AD=0.0468P	AS=0.0408P	PD=0.68U	PS=0.68U
MavI6/avD1_1	avI6/avC11	CLK_h35	avI6/avC9_h9	GND_h119 gpdk090_nmos1v
+ L=0.1U	W=0.24U
+ AD=0.0528P	AS=0.0468P	PD=0.68U	PS=0.68U
MavI6/avD1_2	avI6/avC13	avC13_h33	avI6/avC11	GND_h119
+ gpdk090_nmos1v	L=0.1U	W=0.24U
+ AD=0.0816P	AS=0.0528P	PD=1.16U	PS=0.68U
MavI6/avD1_3	GND_h169	GND_h26	avI6/avC13_h5	GND_h119 gpdk090_nmos1v
+ L=0.1U	W=0.12U
+ AD=0.0408P	AS=0.0696P	PD=0.68U	PS=1.16U
MavI6/avD1_4	avI6/avC13_h8	Q1_h8	GND_h169	GND_h119 gpdk090_nmos1v
+ L=0.1U	W=0.12U
+ AD=0.0696P	AS=0.0408P	PD=1.16U	PS=0.68U
MavI6/avD1_5	GND_h168	avI6/avC11_h8	Q1_h3	GND_h119 gpdk090_nmos1v
+ L=0.1U	W=0.12U
+ AD=0.0408P	AS=0.0696P	PD=0.68U	PS=1.16U
MavI6/avD1_6	Q1_h11	RST_h24	GND_h168	GND_h119 gpdk090_nmos1v	L=0.1U
+ W=0.12U
+ AD=0.0696P	AS=0.0408P	PD=1.16U	PS=0.68U
MavI6/avD1_7	avI6/avC10	avC13_h23	Q0_h13	GND_h119 gpdk090_nmos1v
+ L=0.1U	W=0.24U
+ AD=0.0528P	AS=0.0816P	PD=0.68U	PS=1.16U
MavI6/avD1_8	avI6/avC12	CLK_h29	avI6/avC10	GND_h119 gpdk090_nmos1v
+ L=0.1U	W=0.24U
+ AD=0.0816P	AS=0.0528P	PD=1.16U	PS=0.68U
MavI6/avD1_9	GND_h171	RST_h18	avI6/avC12_h5	GND_h119 gpdk090_nmos1v
+ L=0.1U	W=0.12U
+ AD=0.0408P	AS=0.0696P	PD=0.68U	PS=1.16U
MavI6/avD1_10	avI6/avC12_h8	avI6/avC9_h6	GND_h171	GND_h119
+ gpdk090_nmos1v	L=0.1U	W=0.12U
+ AD=0.0696P	AS=0.0408P	PD=1.16U	PS=0.68U
MavI6/avD1_11	GND_h170	avI6/avC10_h8	avI6/avC9_h3	GND_h119
+ gpdk090_nmos1v	L=0.1U	W=0.12U
+ AD=0.0408P	AS=0.0696P	PD=0.68U	PS=1.16U
MavI6/avD1_12	avI6/avC9_h9	GND_h18	GND_h170	GND_h119 gpdk090_nmos1v
+ L=0.1U	W=0.12U
+ AD=0.0468P	AS=0.0408P	PD=0.68U	PS=0.68U
MavI5/avD1_1	avI5/avC11	CLK_h22	avI5/avC9_h9	GND_h119 gpdk090_nmos1v
+ L=0.1U	W=0.24U
+ AD=0.0528P	AS=0.0468P	PD=0.68U	PS=0.68U
MavI5/avD1_2	avI5/avC13	avC13_h20	avI5/avC11	GND_h119
+ gpdk090_nmos1v	L=0.1U	W=0.24U
+ AD=0.0816P	AS=0.0528P	PD=1.16U	PS=0.68U
MavI5/avD1_3	GND_h173	RST_h11	avI5/avC13_h5	GND_h119 gpdk090_nmos1v
+ L=0.1U	W=0.12U
+ AD=0.0408P	AS=0.0696P	PD=0.68U	PS=1.16U
MavI5/avD1_4	avI5/avC13_h8	Q0_h8	GND_h173	GND_h119 gpdk090_nmos1v
+ L=0.1U	W=0.12U
+ AD=0.0696P	AS=0.0408P	PD=1.16U	PS=0.68U
MavI5/avD1_5	GND_h172	avI5/avC11_h8	Q0_h3	GND_h119 gpdk090_nmos1v
+ L=0.1U	W=0.12U
+ AD=0.0408P	AS=0.0696P	PD=0.68U	PS=1.16U
MavI5/avD1_6	Q0_h11	GND_h12	GND_h172	GND_h119 gpdk090_nmos1v	L=0.1U
+ W=0.12U
+ AD=0.0696P	AS=0.0408P	PD=1.16U	PS=0.68U
MavI5/avD1_7	avI5/avC10	avC13_h10	avC14	GND_h119 gpdk090_nmos1v
+ L=0.1U	W=0.24U
+ AD=0.0528P	AS=0.0816P	PD=0.68U	PS=1.16U
MavI5/avD1_8	avI5/avC12	CLK_h16	avI5/avC10	GND_h119 gpdk090_nmos1v
+ L=0.1U	W=0.24U
+ AD=0.0816P	AS=0.0528P	PD=1.16U	PS=0.68U
MavI5/avD1_9	GND_h175	GND_h6	avI5/avC12_h5	GND_h119 gpdk090_nmos1v
+ L=0.1U	W=0.12U
+ AD=0.0408P	AS=0.0696P	PD=0.68U	PS=1.16U
MavI5/avD1_10	avI5/avC12_h6	avI5/avC9_h6	GND_h175	GND_h119
+ gpdk090_nmos1v	L=0.1U	W=0.12U
+ AD=0.0696P	AS=0.0408P	PD=1.16U	PS=0.68U
MavI5/avD1_11	GND_h174	avI5/avC10_h8	avI5/avC9_h3	GND_h119
+ gpdk090_nmos1v	L=0.1U	W=0.12U
+ AD=0.0408P	AS=0.0696P	PD=0.68U	PS=1.16U
MavI5/avD1_12	avI5/avC9_h9	RST_h6	GND_h174	GND_h119 gpdk090_nmos1v
+ L=0.1U	W=0.12U
+ AD=0.0468P	AS=0.0408P	PD=0.68U	PS=0.68U
MavI4/avD1_1	avI4/avC6_h3	avC16_h12	GND_h141	GND_h119
+ gpdk090_nmos1v	L=0.1U	W=0.12U
+ AD=0.0696P	AS=0.0696P	PD=1.16U	PS=1.16U
MavI4/avD1_2	avI4/avC8	avI4/avC6_h8	GND_h140	GND_h119
+ gpdk090_nmos1v	L=0.1U	W=0.24U
+ AD=0.0528P	AS=0.0816P	PD=0.68U	PS=1.16U
MavI4/avD1_3	avC14_h11	avI4/avC7_h4	avI4/avC8	GND_h119
+ gpdk090_nmos1v	L=0.1U	W=0.24U
+ AD=0.0528P	AS=0.0528P	PD=0.68U	PS=0.68U
MavI4/avD1_4	avI4/avC9	avC15_h11	avC14_h11	GND_h119
+ gpdk090_nmos1v	L=0.1U	W=0.24U
+ AD=0.0528P	AS=0.0528P	PD=0.68U	PS=0.68U
MavI4/avD1_5	GND_h139	avC16_h18	avI4/avC9	GND_h119
+ gpdk090_nmos1v	L=0.1U	W=0.24U
+ AD=0.0816P	AS=0.0528P	PD=1.16U	PS=0.68U
MavI4/avD1_6	avI4/avC7_h7	avC15_h18	GND_h118	GND_h119
+ gpdk090_nmos1v	L=0.1U	W=0.12U
+ AD=0.0696P	AS=0.0696P	PD=1.16U	PS=1.16U
MavI3/avD1_1	avC16	avI3/avC6_h5	Q7_h14	GND_h119 gpdk090_nmos1v	L=0.1U
+ W=0.12U
+ AD=0.0468P	AS=0.1992P	PD=0.68U	PS=2.24U
MavI3/avD1_2	avI3/avC6_h6	Q7_h19	avC16	GND_h119 gpdk090_nmos1v	L=0.1U
+ W=0.24U
+ AD=0.0468P	AS=0.0468P	PD=0.68U	PS=0.68U
MavI3/avD1_3	GND_h142	Q6_h33	avI3/avC6_h6	GND_h119 gpdk090_nmos1v
+ L=0.1U	W=0.12U
+ AD=0.0696P	AS=0.0468P	PD=1.16U	PS=0.68U
MavI2/avD1_1	avC15	avI2/avC6_h5	Q5_h22	GND_h119 gpdk090_nmos1v	L=0.1U
+ W=0.12U
+ AD=0.0468P	AS=0.1992P	PD=0.68U	PS=2.24U
MavI2/avD1_2	avI2/avC6_h6	Q5_h27	avC15	GND_h119 gpdk090_nmos1v	L=0.1U
+ W=0.24U
+ AD=0.0468P	AS=0.0468P	PD=0.68U	PS=0.68U
MavI2/avD1_3	GND_h143	Q0_h33	avI2/avC6_h6	GND_h119 gpdk090_nmos1v
+ L=0.1U	W=0.12U
+ AD=0.0696P	AS=0.0468P	PD=1.16U	PS=0.68U
MavI1/avD1_1	avC13_h3	CLK_h8	GND_h177	GND_h119 gpdk090_nmos1v
+ L=0.1U	W=0.24U
+ AD=0.0528P	AS=0.0816P	PD=0.68U	PS=1.16U
MavI1/avD1_2	GND_h178	CLK_h12	avC13_h3	GND_h119 gpdk090_nmos1v
+ L=0.1U	W=0.24U
+ AD=0.0816P	AS=0.0528P	PD=1.16U	PS=0.68U
MavI12/avD7_1	avI12/avC11_h3	avC13_h110	avI12/avC9_h7	VDD_h2 gpdk090_pmos1v
+ L=0.1U	W=0.48U
+ AD=0.1056P	AS=0.2352P	PD=0.92U	PS=1.46U
MavI12/avD7_2	avI12/avC13_h3	CLK_h116	avI12/avC11_h3	VDD_h2 gpdk090_pmos1v
+ L=0.1U	W=0.48U
+ AD=0.1056P	AS=0.1056P	PD=0.92U	PS=0.92U
MavI12/avD7_3	avI12/avC16	GND_h115	avI12/avC13_h3	VDD_h2 gpdk090_pmos1v
+ L=0.1U	W=0.48U
+ AD=0.1056P	AS=0.1056P	PD=0.92U	PS=0.92U
MavI12/avD7_4	VDD_h27	Q7_h7	avI12/avC16	VDD_h2 gpdk090_pmos1v	L=0.1U	W=0.48U
+ AD=0.1632P	AS=0.1056P	PD=1.64U	PS=0.92U
MavI12/avD7_5	avI12/avC17	avI12/avC11_h7	VDD_h26	VDD_h2 gpdk090_pmos1v	L=0.1U
+ W=0.48U
+ AD=0.1056P	AS=0.1632P	PD=0.92U	PS=1.64U
MavI12/avD7_6	Q7_h9	RST_h95	avI12/avC17	VDD_h2 gpdk090_pmos1v	L=0.1U	W=0.48U
+ AD=0.1632P	AS=0.1056P	PD=1.64U	PS=0.92U
MavI12/avD7_7	avI12/avC10_h3	CLK_h106	Q6_h21	VDD_h2 gpdk090_pmos1v	L=0.1U
+ W=0.48U
+ AD=0.1056P	AS=0.1632P	PD=0.92U	PS=1.64U
MavI12/avD7_8	avI12/avC12_h3	avC13_h105	avI12/avC10_h3	VDD_h2 gpdk090_pmos1v
+ L=0.1U	W=0.48U
+ AD=0.1056P	AS=0.1056P	PD=0.92U	PS=0.92U
MavI12/avD7_9	avI12/avC14	RST_h88	avI12/avC12_h3	VDD_h2 gpdk090_pmos1v	L=0.1U
+ W=0.48U
+ AD=0.1056P	AS=0.1056P	PD=0.92U	PS=0.92U
MavI12/avD7_10	VDD_h29	avI12/avC9_h5	avI12/avC14	VDD_h2 gpdk090_pmos1v	L=0.1U
+ W=0.48U
+ AD=0.1632P	AS=0.1056P	PD=1.64U	PS=0.92U
MavI12/avD7_11	avI12/avC15	avI12/avC10_h7	VDD_h28	VDD_h2 gpdk090_pmos1v	L=0.1U
+ W=0.48U
+ AD=0.1056P	AS=0.1632P	PD=0.92U	PS=1.64U
MavI12/avD7_12	avI12/avC9_h7	GND_h106	avI12/avC15	VDD_h2 gpdk090_pmos1v
+ L=0.1U	W=0.48U
+ AD=0.2352P	AS=0.1056P	PD=1.46U	PS=0.92U
MavI11/avD7_1	avI11/avC11_h3	avC13_h97	avI11/avC9_h7	VDD_h2 gpdk090_pmos1v
+ L=0.1U	W=0.48U
+ AD=0.1056P	AS=0.2352P	PD=0.92U	PS=1.46U
MavI11/avD7_2	avI11/avC13_h3	CLK_h103	avI11/avC11_h3	VDD_h2 gpdk090_pmos1v
+ L=0.1U	W=0.48U
+ AD=0.1056P	AS=0.1056P	PD=0.92U	PS=0.92U
MavI11/avD7_3	avI11/avC16	GND_h100	avI11/avC13_h3	VDD_h2 gpdk090_pmos1v
+ L=0.1U	W=0.48U
+ AD=0.1056P	AS=0.1056P	PD=0.92U	PS=0.92U
MavI11/avD7_4	VDD_h31	Q6_h7	avI11/avC16	VDD_h2 gpdk090_pmos1v	L=0.1U	W=0.48U
+ AD=0.1632P	AS=0.1056P	PD=1.64U	PS=0.92U
MavI11/avD7_5	avI11/avC17	avI11/avC11_h7	VDD_h30	VDD_h2 gpdk090_pmos1v	L=0.1U
+ W=0.48U
+ AD=0.1056P	AS=0.1632P	PD=0.92U	PS=1.64U
MavI11/avD7_6	Q6_h9	RST_h83	avI11/avC17	VDD_h2 gpdk090_pmos1v	L=0.1U	W=0.48U
+ AD=0.1632P	AS=0.1056P	PD=1.64U	PS=0.92U
MavI11/avD7_7	avI11/avC10_h3	CLK_h93	Q5_h21	VDD_h2 gpdk090_pmos1v	L=0.1U	W=0.48U
+ AD=0.1056P	AS=0.1632P	PD=0.92U	PS=1.64U
MavI11/avD7_8	avI11/avC12_h3	avC13_h92	avI11/avC10_h3	VDD_h2 gpdk090_pmos1v
+ L=0.1U	W=0.48U
+ AD=0.1056P	AS=0.1056P	PD=0.92U	PS=0.92U
MavI11/avD7_9	avI11/avC14	RST_h76	avI11/avC12_h3	VDD_h2 gpdk090_pmos1v	L=0.1U
+ W=0.48U
+ AD=0.1056P	AS=0.1056P	PD=0.92U	PS=0.92U
MavI11/avD7_10	VDD_h33	avI11/avC9_h5	avI11/avC14	VDD_h2 gpdk090_pmos1v	L=0.1U
+ W=0.48U
+ AD=0.1632P	AS=0.1056P	PD=1.64U	PS=0.92U
MavI11/avD7_11	avI11/avC15	avI11/avC10_h7	VDD_h32	VDD_h2 gpdk090_pmos1v	L=0.1U
+ W=0.48U
+ AD=0.1056P	AS=0.1632P	PD=0.92U	PS=1.64U
MavI11/avD7_12	avI11/avC9_h7	GND_h91	avI11/avC15	VDD_h2 gpdk090_pmos1v	L=0.1U
+ W=0.48U
+ AD=0.2352P	AS=0.1056P	PD=1.46U	PS=0.92U
MavI10/avD7_1	avI10/avC11_h3	avC13_h84	avI10/avC9_h7	VDD_h2 gpdk090_pmos1v
+ L=0.1U	W=0.48U
+ AD=0.1056P	AS=0.2352P	PD=0.92U	PS=1.46U
MavI10/avD7_2	avI10/avC13_h3	CLK_h90	avI10/avC11_h3	VDD_h2 gpdk090_pmos1v	L=0.1U
+ W=0.48U
+ AD=0.1056P	AS=0.1056P	PD=0.92U	PS=0.92U
MavI10/avD7_3	avI10/avC16	GND_h85	avI10/avC13_h3	VDD_h2 gpdk090_pmos1v	L=0.1U
+ W=0.48U
+ AD=0.1056P	AS=0.1056P	PD=0.92U	PS=0.92U
MavI10/avD7_4	VDD_h35	Q5_h7	avI10/avC16	VDD_h2 gpdk090_pmos1v	L=0.1U	W=0.48U
+ AD=0.1632P	AS=0.1056P	PD=1.64U	PS=0.92U
MavI10/avD7_5	avI10/avC17	avI10/avC11_h7	VDD_h34	VDD_h2 gpdk090_pmos1v	L=0.1U
+ W=0.48U
+ AD=0.1056P	AS=0.1632P	PD=0.92U	PS=1.64U
MavI10/avD7_6	Q5_h9	RST_h71	avI10/avC17	VDD_h2 gpdk090_pmos1v	L=0.1U	W=0.48U
+ AD=0.1632P	AS=0.1056P	PD=1.64U	PS=0.92U
MavI10/avD7_7	avI10/avC10_h3	CLK_h80	Q4_h21	VDD_h2 gpdk090_pmos1v	L=0.1U	W=0.48U
+ AD=0.1056P	AS=0.1632P	PD=0.92U	PS=1.64U
MavI10/avD7_8	avI10/avC12_h3	avC13_h79	avI10/avC10_h3	VDD_h2 gpdk090_pmos1v
+ L=0.1U	W=0.48U
+ AD=0.1056P	AS=0.1056P	PD=0.92U	PS=0.92U
MavI10/avD7_9	avI10/avC14	RST_h64	avI10/avC12_h3	VDD_h2 gpdk090_pmos1v	L=0.1U
+ W=0.48U
+ AD=0.1056P	AS=0.1056P	PD=0.92U	PS=0.92U
MavI10/avD7_10	VDD_h37	avI10/avC9_h5	avI10/avC14	VDD_h2 gpdk090_pmos1v	L=0.1U
+ W=0.48U
+ AD=0.1632P	AS=0.1056P	PD=1.64U	PS=0.92U
MavI10/avD7_11	avI10/avC15	avI10/avC10_h7	VDD_h36	VDD_h2 gpdk090_pmos1v	L=0.1U
+ W=0.48U
+ AD=0.1056P	AS=0.1632P	PD=0.92U	PS=1.64U
MavI10/avD7_12	avI10/avC9_h7	GND_h76	avI10/avC15	VDD_h2 gpdk090_pmos1v	L=0.1U
+ W=0.48U
+ AD=0.2352P	AS=0.1056P	PD=1.46U	PS=0.92U
MavI9/avD7_1	avI9/avC11_h3	avC13_h71	avI9/avC9_h7	VDD_h2 gpdk090_pmos1v
+ L=0.1U	W=0.48U
+ AD=0.1056P	AS=0.2352P	PD=0.92U	PS=1.46U
MavI9/avD7_2	avI9/avC13_h3	CLK_h77	avI9/avC11_h3	VDD_h2 gpdk090_pmos1v	L=0.1U
+ W=0.48U
+ AD=0.1056P	AS=0.1056P	PD=0.92U	PS=0.92U
MavI9/avD7_3	avI9/avC16	GND_h70	avI9/avC13_h3	VDD_h2 gpdk090_pmos1v	L=0.1U
+ W=0.48U
+ AD=0.1056P	AS=0.1056P	PD=0.92U	PS=0.92U
MavI9/avD7_4	VDD_h39	Q4_h7	avI9/avC16	VDD_h2 gpdk090_pmos1v	L=0.1U	W=0.48U
+ AD=0.1632P	AS=0.1056P	PD=1.64U	PS=0.92U
MavI9/avD7_5	avI9/avC17	avI9/avC11_h7	VDD_h38	VDD_h2 gpdk090_pmos1v	L=0.1U
+ W=0.48U
+ AD=0.1056P	AS=0.1632P	PD=0.92U	PS=1.64U
MavI9/avD7_6	Q4_h9	RST_h59	avI9/avC17	VDD_h2 gpdk090_pmos1v	L=0.1U	W=0.48U
+ AD=0.1632P	AS=0.1056P	PD=1.64U	PS=0.92U
MavI9/avD7_7	avI9/avC10_h3	CLK_h67	Q3_h21	VDD_h2 gpdk090_pmos1v	L=0.1U	W=0.48U
+ AD=0.1056P	AS=0.1632P	PD=0.92U	PS=1.64U
MavI9/avD7_8	avI9/avC12_h3	avC13_h66	avI9/avC10_h3	VDD_h2 gpdk090_pmos1v
+ L=0.1U	W=0.48U
+ AD=0.1056P	AS=0.1056P	PD=0.92U	PS=0.92U
MavI9/avD7_9	avI9/avC14	RST_h52	avI9/avC12_h3	VDD_h2 gpdk090_pmos1v	L=0.1U
+ W=0.48U
+ AD=0.1056P	AS=0.1056P	PD=0.92U	PS=0.92U
MavI9/avD7_10	VDD_h41	avI9/avC9_h5	avI9/avC14	VDD_h2 gpdk090_pmos1v	L=0.1U
+ W=0.48U
+ AD=0.1632P	AS=0.1056P	PD=1.64U	PS=0.92U
MavI9/avD7_11	avI9/avC15	avI9/avC10_h7	VDD_h40	VDD_h2 gpdk090_pmos1v	L=0.1U
+ W=0.48U
+ AD=0.1056P	AS=0.1632P	PD=0.92U	PS=1.64U
MavI9/avD7_12	avI9/avC9_h7	GND_h61	avI9/avC15	VDD_h2 gpdk090_pmos1v	L=0.1U
+ W=0.48U
+ AD=0.2352P	AS=0.1056P	PD=1.46U	PS=0.92U
MavI8/avD7_1	avI8/avC11_h3	avC13_h58	avI8/avC9_h7	VDD_h2 gpdk090_pmos1v
+ L=0.1U	W=0.48U
+ AD=0.1056P	AS=0.2352P	PD=0.92U	PS=1.46U
MavI8/avD7_2	avI8/avC13_h3	CLK_h64	avI8/avC11_h3	VDD_h2 gpdk090_pmos1v	L=0.1U
+ W=0.48U
+ AD=0.1056P	AS=0.1056P	PD=0.92U	PS=0.92U
MavI8/avD7_3	avI8/avC16	GND_h55	avI8/avC13_h3	VDD_h2 gpdk090_pmos1v	L=0.1U
+ W=0.48U
+ AD=0.1056P	AS=0.1056P	PD=0.92U	PS=0.92U
MavI8/avD7_4	VDD_h43	Q3_h7	avI8/avC16	VDD_h2 gpdk090_pmos1v	L=0.1U	W=0.48U
+ AD=0.1632P	AS=0.1056P	PD=1.64U	PS=0.92U
MavI8/avD7_5	avI8/avC17	avI8/avC11_h7	VDD_h42	VDD_h2 gpdk090_pmos1v	L=0.1U
+ W=0.48U
+ AD=0.1056P	AS=0.1632P	PD=0.92U	PS=1.64U
MavI8/avD7_6	Q3_h9	RST_h47	avI8/avC17	VDD_h2 gpdk090_pmos1v	L=0.1U	W=0.48U
+ AD=0.1632P	AS=0.1056P	PD=1.64U	PS=0.92U
MavI8/avD7_7	avI8/avC10_h3	CLK_h54	Q2_h21	VDD_h2 gpdk090_pmos1v	L=0.1U	W=0.48U
+ AD=0.1056P	AS=0.1632P	PD=0.92U	PS=1.64U
MavI8/avD7_8	avI8/avC12_h3	avC13_h53	avI8/avC10_h3	VDD_h2 gpdk090_pmos1v
+ L=0.1U	W=0.48U
+ AD=0.1056P	AS=0.1056P	PD=0.92U	PS=0.92U
MavI8/avD7_9	avI8/avC14	RST_h40	avI8/avC12_h3	VDD_h2 gpdk090_pmos1v	L=0.1U
+ W=0.48U
+ AD=0.1056P	AS=0.1056P	PD=0.92U	PS=0.92U
MavI8/avD7_10	VDD_h45	avI8/avC9_h5	avI8/avC14	VDD_h2 gpdk090_pmos1v	L=0.1U
+ W=0.48U
+ AD=0.1632P	AS=0.1056P	PD=1.64U	PS=0.92U
MavI8/avD7_11	avI8/avC15	avI8/avC10_h7	VDD_h44	VDD_h2 gpdk090_pmos1v	L=0.1U
+ W=0.48U
+ AD=0.1056P	AS=0.1632P	PD=0.92U	PS=1.64U
MavI8/avD7_12	avI8/avC9_h7	GND_h46	avI8/avC15	VDD_h2 gpdk090_pmos1v	L=0.1U
+ W=0.48U
+ AD=0.2352P	AS=0.1056P	PD=1.46U	PS=0.92U
MavI7/avD7_1	avI7/avC11_h3	avC13_h45	avI7/avC9_h7	VDD_h2 gpdk090_pmos1v
+ L=0.1U	W=0.48U
+ AD=0.1056P	AS=0.2352P	PD=0.92U	PS=1.46U
MavI7/avD7_2	avI7/avC13_h3	CLK_h51	avI7/avC11_h3	VDD_h2 gpdk090_pmos1v	L=0.1U
+ W=0.48U
+ AD=0.1056P	AS=0.1056P	PD=0.92U	PS=0.92U
MavI7/avD7_3	avI7/avC16	GND_h40	avI7/avC13_h3	VDD_h2 gpdk090_pmos1v	L=0.1U
+ W=0.48U
+ AD=0.1056P	AS=0.1056P	PD=0.92U	PS=0.92U
MavI7/avD7_4	VDD_h47	Q2_h7	avI7/avC16	VDD_h2 gpdk090_pmos1v	L=0.1U	W=0.48U
+ AD=0.1632P	AS=0.1056P	PD=1.64U	PS=0.92U
MavI7/avD7_5	avI7/avC17	avI7/avC11_h7	VDD_h46	VDD_h2 gpdk090_pmos1v	L=0.1U
+ W=0.48U
+ AD=0.1056P	AS=0.1632P	PD=0.92U	PS=1.64U
MavI7/avD7_6	Q2_h9	RST_h35	avI7/avC17	VDD_h2 gpdk090_pmos1v	L=0.1U	W=0.48U
+ AD=0.1632P	AS=0.1056P	PD=1.64U	PS=0.92U
MavI7/avD7_7	avI7/avC10_h3	CLK_h41	Q1_h21	VDD_h2 gpdk090_pmos1v	L=0.1U	W=0.48U
+ AD=0.1056P	AS=0.1632P	PD=0.92U	PS=1.64U
MavI7/avD7_8	avI7/avC12_h3	avC13_h40	avI7/avC10_h3	VDD_h2 gpdk090_pmos1v
+ L=0.1U	W=0.48U
+ AD=0.1056P	AS=0.1056P	PD=0.92U	PS=0.92U
MavI7/avD7_9	avI7/avC14	RST_h28	avI7/avC12_h3	VDD_h2 gpdk090_pmos1v	L=0.1U
+ W=0.48U
+ AD=0.1056P	AS=0.1056P	PD=0.92U	PS=0.92U
MavI7/avD7_10	VDD_h49	avI7/avC9_h5	avI7/avC14	VDD_h2 gpdk090_pmos1v	L=0.1U
+ W=0.48U
+ AD=0.1632P	AS=0.1056P	PD=1.64U	PS=0.92U
MavI7/avD7_11	avI7/avC15	avI7/avC10_h7	VDD_h48	VDD_h2 gpdk090_pmos1v	L=0.1U
+ W=0.48U
+ AD=0.1056P	AS=0.1632P	PD=0.92U	PS=1.64U
MavI7/avD7_12	avI7/avC9_h7	GND_h31	avI7/avC15	VDD_h2 gpdk090_pmos1v	L=0.1U
+ W=0.48U
+ AD=0.2352P	AS=0.1056P	PD=1.46U	PS=0.92U
MavI6/avD7_1	avI6/avC11_h3	avC13_h32	avI6/avC9_h7	VDD_h2 gpdk090_pmos1v
+ L=0.1U	W=0.48U
+ AD=0.1056P	AS=0.2352P	PD=0.92U	PS=1.46U
MavI6/avD7_2	avI6/avC13_h3	CLK_h38	avI6/avC11_h3	VDD_h2 gpdk090_pmos1v	L=0.1U
+ W=0.48U
+ AD=0.1056P	AS=0.1056P	PD=0.92U	PS=0.92U
MavI6/avD7_3	avI6/avC16	GND_h25	avI6/avC13_h3	VDD_h2 gpdk090_pmos1v	L=0.1U
+ W=0.48U
+ AD=0.1056P	AS=0.1056P	PD=0.92U	PS=0.92U
MavI6/avD7_4	VDD_h51	Q1_h7	avI6/avC16	VDD_h2 gpdk090_pmos1v	L=0.1U	W=0.48U
+ AD=0.1632P	AS=0.1056P	PD=1.64U	PS=0.92U
MavI6/avD7_5	avI6/avC17	avI6/avC11_h7	VDD_h50	VDD_h2 gpdk090_pmos1v	L=0.1U
+ W=0.48U
+ AD=0.1056P	AS=0.1632P	PD=0.92U	PS=1.64U
MavI6/avD7_6	Q1_h9	RST_h23	avI6/avC17	VDD_h2 gpdk090_pmos1v	L=0.1U	W=0.48U
+ AD=0.1632P	AS=0.1056P	PD=1.64U	PS=0.92U
MavI6/avD7_7	avI6/avC10_h3	CLK_h28	Q0_h21	VDD_h2 gpdk090_pmos1v	L=0.1U	W=0.48U
+ AD=0.1056P	AS=0.1632P	PD=0.92U	PS=1.64U
MavI6/avD7_8	avI6/avC12_h3	avC13_h27	avI6/avC10_h3	VDD_h2 gpdk090_pmos1v
+ L=0.1U	W=0.48U
+ AD=0.1056P	AS=0.1056P	PD=0.92U	PS=0.92U
MavI6/avD7_9	avI6/avC14	RST_h16	avI6/avC12_h3	VDD_h2 gpdk090_pmos1v	L=0.1U
+ W=0.48U
+ AD=0.1056P	AS=0.1056P	PD=0.92U	PS=0.92U
MavI6/avD7_10	VDD_h53	avI6/avC9_h5	avI6/avC14	VDD_h2 gpdk090_pmos1v	L=0.1U
+ W=0.48U
+ AD=0.1632P	AS=0.1056P	PD=1.64U	PS=0.92U
MavI6/avD7_11	avI6/avC15	avI6/avC10_h7	VDD_h52	VDD_h2 gpdk090_pmos1v	L=0.1U
+ W=0.48U
+ AD=0.1056P	AS=0.1632P	PD=0.92U	PS=1.64U
MavI6/avD7_12	avI6/avC9_h7	GND_h16	avI6/avC15	VDD_h2 gpdk090_pmos1v	L=0.1U
+ W=0.48U
+ AD=0.2352P	AS=0.1056P	PD=1.46U	PS=0.92U
MavI5/avD7_1	avI5/avC11_h3	avC13_h19	avI5/avC9_h7	VDD_h2 gpdk090_pmos1v
+ L=0.1U	W=0.48U
+ AD=0.1056P	AS=0.2352P	PD=0.92U	PS=1.46U
MavI5/avD7_2	avI5/avC13_h3	CLK_h25	avI5/avC11_h3	VDD_h2 gpdk090_pmos1v	L=0.1U
+ W=0.48U
+ AD=0.1056P	AS=0.1056P	PD=0.92U	PS=0.92U
MavI5/avD7_3	avI5/avC16	RST_h10	avI5/avC13_h3	VDD_h2 gpdk090_pmos1v	L=0.1U
+ W=0.48U
+ AD=0.1056P	AS=0.1056P	PD=0.92U	PS=0.92U
MavI5/avD7_4	VDD_h55	Q0_h7	avI5/avC16	VDD_h2 gpdk090_pmos1v	L=0.1U	W=0.48U
+ AD=0.1632P	AS=0.1056P	PD=1.64U	PS=0.92U
MavI5/avD7_5	avI5/avC17	avI5/avC11_h7	VDD_h54	VDD_h2 gpdk090_pmos1v	L=0.1U
+ W=0.48U
+ AD=0.1056P	AS=0.1632P	PD=0.92U	PS=1.64U
MavI5/avD7_6	Q0_h9	GND_h11	avI5/avC17	VDD_h2 gpdk090_pmos1v	L=0.1U	W=0.48U
+ AD=0.1632P	AS=0.1056P	PD=1.64U	PS=0.92U
MavI5/avD7_7	avI5/avC10_h3	CLK_h15	avC14_h8	VDD_h2 gpdk090_pmos1v	L=0.1U
+ W=0.48U
+ AD=0.1056P	AS=0.1632P	PD=0.92U	PS=1.64U
MavI5/avD7_8	avI5/avC12_h3	avC13_h14	avI5/avC10_h3	VDD_h2 gpdk090_pmos1v
+ L=0.1U	W=0.48U
+ AD=0.1056P	AS=0.1056P	PD=0.92U	PS=0.92U
MavI5/avD7_9	avI5/avC14	GND_h4	avI5/avC12_h3	VDD_h2 gpdk090_pmos1v	L=0.1U
+ W=0.48U
+ AD=0.1056P	AS=0.1056P	PD=0.92U	PS=0.92U
MavI5/avD7_10	VDD_h57	avI5/avC9_h5	avI5/avC14	VDD_h2 gpdk090_pmos1v	L=0.1U
+ W=0.48U
+ AD=0.1632P	AS=0.1056P	PD=1.64U	PS=0.92U
MavI5/avD7_11	avI5/avC15	avI5/avC10_h7	VDD_h56	VDD_h2 gpdk090_pmos1v	L=0.1U
+ W=0.48U
+ AD=0.1056P	AS=0.1632P	PD=0.92U	PS=1.64U
MavI5/avD7_12	avI5/avC9_h7	RST_h4	avI5/avC15	VDD_h2 gpdk090_pmos1v	L=0.1U
+ W=0.48U
+ AD=0.2352P	AS=0.1056P	PD=1.46U	PS=0.92U
MavI4/avD7_1	VDD_h23	avC16_h11	avI4/avC6	VDD_h2 gpdk090_pmos1v	L=0.1U
+ W=0.24U
+ AD=0.0816P	AS=0.0816P	PD=1.16U	PS=1.16U
MavI4/avD7_2	avC14_h9	avI4/avC6_h7	avI4/avC10_h2	VDD_h2 gpdk090_pmos1v
+ L=0.1U	W=0.48U
+ AD=0.1056P	AS=0.1632P	PD=0.92U	PS=1.64U
MavI4/avD7_3	avI4/avC10_h4	avI4/avC7_h3	avC14_h9	VDD_h2 gpdk090_pmos1v
+ L=0.1U	W=0.48U
+ AD=0.1056P	AS=0.1056P	PD=0.92U	PS=0.92U
MavI4/avD7_4	VDD_h22	avC15_h10	avI4/avC10_h4	VDD_h2 gpdk090_pmos1v	L=0.1U
+ W=0.48U
+ AD=0.1056P	AS=0.1056P	PD=0.92U	PS=0.92U
MavI4/avD7_5	avI4/avC10_h6	avC16_h17	VDD_h22	VDD_h2 gpdk090_pmos1v	L=0.1U
+ W=0.48U
+ AD=0.1632P	AS=0.1056P	PD=1.64U	PS=0.92U
MavI4/avD7_6	VDD_h1	avC15_h16	avI4/avC7_h5	VDD_h2 gpdk090_pmos1v	L=0.1U
+ W=0.24U
+ AD=0.0816P	AS=0.0816P	PD=1.16U	PS=1.16U
MavI3/avD7_1	VDD_h24	Q6_h25	avI3/avC6	VDD_h2 gpdk090_pmos1v	L=0.1U	W=0.24U
+ AD=0.0816P	AS=0.0816P	PD=1.16U	PS=1.16U
MavI3/avD7_2	avC16_h3	Q7_h18	Q6_h29	VDD_h2 gpdk090_pmos1v	L=0.1U	W=0.48U
+ AD=0.0936P	AS=0.1632P	PD=0.92U	PS=1.64U
MavI3/avD7_3	Q7_h20	Q6_h32	avC16_h3	VDD_h2 gpdk090_pmos1v	L=0.1U	W=0.24U
+ AD=0.0816P	AS=0.0936P	PD=1.16U	PS=0.92U
MavI2/avD7_1	VDD_h25	Q0_h25	avI2/avC6	VDD_h2 gpdk090_pmos1v	L=0.1U	W=0.24U
+ AD=0.0816P	AS=0.0816P	PD=1.16U	PS=1.16U
MavI2/avD7_2	avC15_h3	Q5_h26	Q0_h27	VDD_h2 gpdk090_pmos1v	L=0.1U	W=0.48U
+ AD=0.0936P	AS=0.1632P	PD=0.92U	PS=1.64U
MavI2/avD7_3	Q5_h28	Q0_h32	avC15_h3	VDD_h2 gpdk090_pmos1v	L=0.1U	W=0.24U
+ AD=0.0816P	AS=0.0936P	PD=1.16U	PS=0.92U
MavI1/avD7_1	avC13	CLK_h6	VDD_h60	VDD_h2 gpdk090_pmos1v	L=0.1U	W=0.48U
+ AD=0.1056P	AS=0.1632P	PD=0.92U	PS=1.64U
MavI1/avD7_2	VDD_h58	CLK_h11	avC13	VDD_h2 gpdk090_pmos1v	L=0.1U	W=0.48U
+ AD=0.1632P	AS=0.1056P	PD=1.64U	PS=0.92U
Rj1	CLK_h6	CLK_h7	   36.5435
Rj2	CLK_h7	CLK_h8	   48.5435
Rj3	CLK_h1	CLK_h7	   10.0000
Rj4	CLK_h11	CLK_h9	   36.5435
Rj5	CLK_h9	CLK_h12	   48.5435
Rj6	avC13_h10	avC13_h8	   48.5435
Rj7	CLK_h15	CLK_h13	   36.5435
Rj8	CLK_h13	CLK_h16	   48.5435
Rj9	avC13_h14	avC13_h11	   46.5435
Rj10	GND_h4	GND_h5	   36.5435
Rj11	GND_h5	GND_h6	   54.5435
Rj12	GND_h1	GND_h5	   10.0000
Rj13	avI5/avC9_h5	avI5/avC9	   36.5435
Rj14	avI5/avC9	avI5/avC9_h6	   54.5435
Rj15	avI5/avC10_h7	avI5/avC10_h5	   36.5435
Rj16	avI5/avC10_h5	avI5/avC10_h8	   54.5435
Rj17	RST_h4	RST_h5	   36.5435
Rj18	RST_h5	RST_h6	   54.5435
Rj19	RST_h1	RST_h5	   10.0000
Rj20	CLK_h22	CLK_h19	   58.5435
Rj21	avC13_h19	avC13_h17	   36.5435
Rj22	avC13_h17	avC13_h20	   48.5435
Rj23	CLK_h25	CLK_h23	   36.5435
Rj24	RST_h10	RST_h7	   36.5435
Rj25	RST_h7	RST_h11	   54.5435
Rj26	Q0_h7	Q0_h1	   36.5435
Rj27	Q0_h1	Q0_h8	   54.5435
Rj28	avI5/avC11_h7	avI5/avC11_h5	   36.5435
Rj29	avI5/avC11_h5	avI5/avC11_h8	   54.5435
Rj30	GND_h11	GND_h7	   36.5435
Rj31	GND_h7	GND_h12	   54.5435
Rj32	avC13_h23	avC13_h21	   48.5435
Rj33	CLK_h28	CLK_h26	   36.5435
Rj34	CLK_h26	CLK_h29	   48.5435
Rj35	avC13_h27	avC13_h24	   46.5435
Rj36	RST_h16	RST_h17	   36.5435
Rj37	RST_h17	RST_h18	   54.5435
Rj38	RST_h13	RST_h17	   10.0000
Rj39	avI6/avC9_h5	avI6/avC9	   36.5435
Rj40	avI6/avC9	avI6/avC9_h6	   54.5435
Rj41	avI6/avC10_h7	avI6/avC10_h5	   36.5435
Rj42	avI6/avC10_h5	avI6/avC10_h8	   54.5435
Rj43	GND_h16	GND_h17	   36.5435
Rj44	GND_h17	GND_h18	   54.5435
Rj45	GND_h13	GND_h17	   10.0000
Rj46	CLK_h35	CLK_h32	   58.5435
Rj47	avC13_h32	avC13_h30	   36.5435
Rj48	avC13_h30	avC13_h33	   48.5435
Rj49	CLK_h38	CLK_h36	   36.5435
Rj50	GND_h25	GND_h23	   36.5435
Rj51	GND_h23	GND_h26	   54.5435
Rj52	Q1_h7	Q1_h1	   36.5435
Rj53	Q1_h1	Q1_h8	   54.5435
Rj54	avI6/avC11_h7	avI6/avC11_h5	   36.5435
Rj55	avI6/avC11_h5	avI6/avC11_h8	   54.5435
Rj56	RST_h23	RST_h21	   36.5435
Rj57	RST_h21	RST_h24	   54.5435
Rj58	avC13_h36	avC13_h34	   48.5435
Rj59	CLK_h41	CLK_h39	   36.5435
Rj60	CLK_h39	CLK_h42	   48.5435
Rj61	avC13_h40	avC13_h37	   46.5435
Rj62	RST_h28	RST_h29	   36.5435
Rj63	RST_h29	RST_h30	   54.5435
Rj64	RST_h25	RST_h29	   10.0000
Rj65	avI7/avC9_h5	avI7/avC9	   36.5435
Rj66	avI7/avC9	avI7/avC9_h6	   54.5435
Rj67	avI7/avC10_h7	avI7/avC10_h5	   36.5435
Rj68	avI7/avC10_h5	avI7/avC10_h8	   54.5435
Rj69	GND_h31	GND_h32	   36.5435
Rj70	GND_h32	GND_h33	   54.5435
Rj71	GND_h28	GND_h32	   10.0000
Rj72	CLK_h48	CLK_h45	   58.5435
Rj73	avC13_h45	avC13_h43	   36.5435
Rj74	avC13_h43	avC13_h46	   48.5435
Rj75	CLK_h51	CLK_h49	   36.5435
Rj76	GND_h40	GND_h38	   36.5435
Rj77	GND_h38	GND_h41	   54.5435
Rj78	Q2_h7	Q2_h1	   36.5435
Rj79	Q2_h1	Q2_h8	   54.5435
Rj80	avI7/avC11_h7	avI7/avC11_h5	   36.5435
Rj81	avI7/avC11_h5	avI7/avC11_h8	   54.5435
Rj82	RST_h35	RST_h33	   36.5435
Rj83	RST_h33	RST_h36	   54.5435
Rj84	avC13_h49	avC13_h47	   48.5435
Rj85	CLK_h54	CLK_h52	   36.5435
Rj86	CLK_h52	CLK_h55	   48.5435
Rj87	avC13_h53	avC13_h50	   46.5435
Rj88	RST_h40	RST_h41	   36.5435
Rj89	RST_h41	RST_h42	   54.5435
Rj90	RST_h37	RST_h41	   10.0000
Rj91	avI8/avC9_h5	avI8/avC9	   36.5435
Rj92	avI8/avC9	avI8/avC9_h6	   54.5435
Rj93	avI8/avC10_h7	avI8/avC10_h5	   36.5435
Rj94	avI8/avC10_h5	avI8/avC10_h8	   54.5435
Rj95	GND_h46	GND_h47	   36.5435
Rj96	GND_h47	GND_h48	   54.5435
Rj97	GND_h43	GND_h47	   10.0000
Rj98	CLK_h61	CLK_h58	   58.5435
Rj99	avC13_h58	avC13_h56	   36.5435
Rj100	avC13_h56	avC13_h59	   48.5435
Rj101	CLK_h64	CLK_h62	   36.5435
Rj102	GND_h55	GND_h53	   36.5435
Rj103	GND_h53	GND_h56	   54.5435
Rj104	Q3_h7	Q3_h1	   36.5435
Rj105	Q3_h1	Q3_h8	   54.5435
Rj106	avI8/avC11_h7	avI8/avC11_h5	   36.5435
Rj107	avI8/avC11_h5	avI8/avC11_h8	   54.5435
Rj108	RST_h47	RST_h45	   36.5435
Rj109	RST_h45	RST_h48	   54.5435
Rj110	avC13_h62	avC13_h60	   48.5435
Rj111	CLK_h67	CLK_h65	   36.5435
Rj112	CLK_h65	CLK_h68	   48.5435
Rj113	avC13_h66	avC13_h63	   46.5435
Rj114	RST_h52	RST_h53	   36.5435
Rj115	RST_h53	RST_h54	   54.5435
Rj116	RST_h49	RST_h53	   10.0000
Rj117	avI9/avC9_h5	avI9/avC9	   36.5435
Rj118	avI9/avC9	avI9/avC9_h6	   54.5435
Rj119	avI9/avC10_h7	avI9/avC10_h5	   36.5435
Rj120	avI9/avC10_h5	avI9/avC10_h8	   54.5435
Rj121	GND_h61	GND_h62	   36.5435
Rj122	GND_h62	GND_h63	   54.5435
Rj123	GND_h58	GND_h62	   10.0000
Rj124	CLK_h74	CLK_h71	   58.5435
Rj125	avC13_h71	avC13_h69	   36.5435
Rj126	avC13_h69	avC13_h72	   48.5435
Rj127	CLK_h77	CLK_h75	   36.5435
Rj128	GND_h70	GND_h68	   36.5435
Rj129	GND_h68	GND_h71	   54.5435
Rj130	Q4_h7	Q4_h1	   36.5435
Rj131	Q4_h1	Q4_h8	   54.5435
Rj132	avI9/avC11_h7	avI9/avC11_h5	   36.5435
Rj133	avI9/avC11_h5	avI9/avC11_h8	   54.5435
Rj134	RST_h59	RST_h57	   36.5435
Rj135	RST_h57	RST_h60	   54.5435
Rj136	avC13_h75	avC13_h73	   48.5435
Rj137	CLK_h80	CLK_h78	   36.5435
Rj138	CLK_h78	CLK_h81	   48.5435
Rj139	avC13_h79	avC13_h76	   46.5435
Rj140	RST_h64	RST_h65	   36.5435
Rj141	RST_h65	RST_h66	   54.5435
Rj142	RST_h61	RST_h65	   10.0000
Rj143	avI10/avC9_h5	avI10/avC9	   36.5435
Rj144	avI10/avC9	avI10/avC9_h6	   54.5435
Rj145	avI10/avC10_h7	avI10/avC10_h5	   36.5435
Rj146	avI10/avC10_h5	avI10/avC10_h8	   54.5435
Rj147	GND_h76	GND_h77	   36.5435
Rj148	GND_h77	GND_h78	   54.5435
Rj149	GND_h73	GND_h77	   10.0000
Rj150	CLK_h87	CLK_h84	   58.5435
Rj151	avC13_h84	avC13_h82	   36.5435
Rj152	avC13_h82	avC13_h85	   48.5435
Rj153	CLK_h90	CLK_h88	   36.5435
Rj154	GND_h85	GND_h83	   36.5435
Rj155	GND_h83	GND_h86	   54.5435
Rj156	Q5_h7	Q5_h1	   36.5435
Rj157	Q5_h1	Q5_h8	   54.5435
Rj158	avI10/avC11_h7	avI10/avC11_h5	   36.5435
Rj159	avI10/avC11_h5	avI10/avC11_h8	   54.5435
Rj160	RST_h71	RST_h69	   36.5435
Rj161	RST_h69	RST_h72	   54.5435
Rj162	avC13_h88	avC13_h86	   48.5435
Rj163	CLK_h93	CLK_h91	   36.5435
Rj164	CLK_h91	CLK_h94	   48.5435
Rj165	avC13_h92	avC13_h89	   46.5435
Rj166	RST_h76	RST_h77	   36.5435
Rj167	RST_h77	RST_h78	   54.5435
Rj168	RST_h73	RST_h77	   10.0000
Rj169	avI11/avC9_h5	avI11/avC9	   36.5435
Rj170	avI11/avC9	avI11/avC9_h6	   54.5435
Rj171	avI11/avC10_h7	avI11/avC10_h5	   36.5435
Rj172	avI11/avC10_h5	avI11/avC10_h8	   54.5435
Rj173	GND_h91	GND_h92	   36.5435
Rj174	GND_h92	GND_h93	   54.5435
Rj175	GND_h88	GND_h92	   10.0000
Rj176	CLK_h100	CLK_h97	   58.5435
Rj177	avC13_h97	avC13_h95	   36.5435
Rj178	avC13_h95	avC13_h98	   48.5435
Rj179	CLK_h103	CLK_h101	   36.5435
Rj180	GND_h100	GND_h98	   36.5435
Rj181	GND_h98	GND_h101	   54.5435
Rj182	Q6_h7	Q6_h1	   36.5435
Rj183	Q6_h1	Q6_h8	   54.5435
Rj184	avI11/avC11_h7	avI11/avC11_h5	   36.5435
Rj185	avI11/avC11_h5	avI11/avC11_h8	   54.5435
Rj186	RST_h83	RST_h81	   36.5435
Rj187	RST_h81	RST_h84	   54.5435
Rj188	avC13_h101	avC13_h99	   48.5435
Rj189	CLK_h106	CLK_h104	   36.5435
Rj190	CLK_h104	CLK_h107	   48.5435
Rj191	avC13_h105	avC13_h102	   46.5435
Rj192	RST_h88	RST_h89	   36.5435
Rj193	RST_h89	RST_h90	   54.5435
Rj194	RST_h85	RST_h89	   10.0000
Rj195	avI12/avC9_h5	avI12/avC9	   36.5435
Rj196	avI12/avC9	avI12/avC9_h6	   54.5435
Rj197	avI12/avC10_h7	avI12/avC10_h5	   36.5435
Rj198	avI12/avC10_h5	avI12/avC10_h8	   54.5435
Rj199	GND_h106	GND_h107	   36.5435
Rj200	GND_h107	GND_h108	   54.5435
Rj201	GND_h103	GND_h107	   10.0000
Rj202	CLK_h113	CLK_h110	   58.5435
Rj203	avC13_h110	avC13_h108	   36.5435
Rj204	avC13_h108	avC13_h111	   48.5435
Rj205	CLK_h116	CLK_h114	   36.5435
Rj206	GND_h115	GND_h113	   36.5435
Rj207	GND_h113	GND_h116	   54.5435
Rj208	Q7_h7	Q7_h1	   36.5435
Rj209	Q7_h1	Q7_h8	   54.5435
Rj210	avI12/avC11_h7	avI12/avC11_h5	   36.5435
Rj211	avI12/avC11_h5	avI12/avC11_h8	   54.5435
Rj212	RST_h95	RST_h93	   36.5435
Rj213	RST_h93	RST_h96	   54.5435
Rj214	Q0_h25	Q0_h22	   58.5435
Rj215	avI2/avC6_h5	avI2/avC6_h3	   54.5435
Rj216	Q5_h26	Q5_h24	   36.5435
Rj217	Q5_h24	Q5_h27	   48.5435
Rj218	Q0_h32	Q0_h30	   48.5435
Rj219	Q0_h30	Q0_h33	   54.5435
Rj220	Q6_h25	Q6_h22	   58.5435
Rj221	avI3/avC6_h5	avI3/avC6_h3	   54.5435
Rj222	Q7_h18	Q7_h16	   36.5435
Rj223	Q7_h16	Q7_h19	   48.5435
Rj224	Q6_h32	Q6_h30	   48.5435
Rj225	Q6_h30	Q6_h33	   54.5435
Rj226	avC16_h11	avC16_h8	   48.5435
Rj227	avC16_h8	avC16_h12	   54.5435
Rj228	avI4/avC6_h7	avI4/avC6_h5	   36.5435
Rj229	avI4/avC6_h5	avI4/avC6_h8	   48.5435
Rj230	avI4/avC7_h3	avI4/avC7	   36.5435
Rj231	avI4/avC7	avI4/avC7_h4	   48.5435
Rj232	avC15_h10	avC15_h8	   36.5435
Rj233	avC15_h8	avC15_h11	   48.5435
Rj234	avC16_h17	avC16_h15	   36.5435
Rj235	avC16_h15	avC16_h18	   48.5435
Rj236	avC15_h16	avC15_h17	   48.5435
Rj237	avC15_h17	avC15_h18	   54.5435
Rj238	avC15_h12	avC15_h17	   10.0000
Ri2	CLK_h1	CLK_h3	    1.8373
Ri3	avC13	avC13_h2	   15.6453
Ri4	avC13_h2	avC13_h4	8.000E-02
Ri6	avC13_h3	avC13_h4	   15.0000
Ri7	CLK_h9	CLK_h10	   11.8373
Ri9	avC14_h2	avC14_h4	    2.2533
Ri10	avC14	avC14_h2	   15.0000
Ri11	avC13_h8	avC13_h9	   11.5813
Ri12	avC14_h8	avC14_h7	   15.1280
Ri13	avI5/avC10	avI5/avC10_h2	   16.7893
Ri14	CLK_h13	CLK_h14	   11.7360
Ri15	avI5/avC10_h3	avI5/avC10_h4	   16.7360
Ri16	avI5/avC12	avI5/avC12_h2	   16.4800
Ri18	avC13_h11	avC13_h13	    1.5813
Ri19	avI5/avC12_h3	avI5/avC12_h4	   15.6453
Ri20	avI5/avC12_h4	avI5/avC12_h5	   15.0800
Ri22	GND_h1	GND_h3	    1.8373
Ri23	avI5/avC9	avI5/avC9_h2	   11.5280
Ri24	avI5/avC12_h6	avI5/avC12_h7	   16.4800
Ri25	avI5/avC9_h3	avI5/avC9_h4	   16.6347
Ri26	avI5/avC10_h5	avI5/avC10_h6	   11.4267
Ri28	RST_h1	RST_h3	    1.8907
Ri29	avI5/avC9_h7	avI5/avC9_h8	   15.4907
Ri30	avI5/avC9_h8	avI5/avC9_h9	   15.2347
Ri32	CLK_h19	CLK_h21	    1.7360
Ri33	avI5/avC11	avI5/avC11_h2	   16.7893
Ri34	avC13_h17	avC13_h18	   11.5813
Ri35	avI5/avC11_h3	avI5/avC11_h4	   16.7360
Ri36	avI5/avC13	avI5/avC13_h2	   16.4800
Ri37	CLK_h23	CLK_h24	   11.7360
Ri38	avI5/avC13_h3	avI5/avC13_h4	   15.6453
Ri39	avI5/avC13_h4	avI5/avC13_h5	   15.0800
Ri40	RST_h7	RST_h8	   11.8907
Ri41	Q0_h1	Q0_h2	   11.5280
Ri42	avI5/avC13_h8	avI5/avC13_h6	   15.0800
Ri44	Q0_h4	Q0_h6	    1.6347
Ri45	Q0_h3	Q0_h4	   15.0000
Ri46	avI5/avC11_h5	avI5/avC11_h6	   11.4267
Ri47	GND_h7	GND_h8	   11.8373
Ri48	Q0_h9	Q0_h10	   15.4907
Ri49	Q0_h10	Q0_h11	   15.2347
Ri51	Q0_h14	Q0_h16	    2.2533
Ri52	Q0_h13	Q0_h14	   15.0000
Ri53	avC13_h21	avC13_h22	   11.5813
Ri54	Q0_h21	Q0_h20	   15.1280
Ri55	avI6/avC10	avI6/avC10_h2	   16.7893
Ri56	CLK_h26	CLK_h27	   11.7360
Ri57	avI6/avC10_h3	avI6/avC10_h4	   16.7360
Ri58	avI6/avC12	avI6/avC12_h2	   16.4800
Ri60	avC13_h24	avC13_h26	    1.5813
Ri61	avI6/avC12_h3	avI6/avC12_h4	   15.6453
Ri62	avI6/avC12_h4	avI6/avC12_h5	   15.0800
Ri64	RST_h13	RST_h15	    1.8373
Ri65	avI6/avC9	avI6/avC9_h2	   11.5280
Ri66	avI6/avC12_h8	avI6/avC12_h6	   15.0800
Ri67	avI6/avC9_h3	avI6/avC9_h4	   16.6347
Ri68	avI6/avC10_h5	avI6/avC10_h6	   11.4267
Ri70	GND_h13	GND_h15	    1.8907
Ri71	avI6/avC9_h7	avI6/avC9_h8	   15.4907
Ri72	avI6/avC9_h8	avI6/avC9_h9	   15.2347
Ri74	CLK_h32	CLK_h34	    1.7360
Ri75	avI6/avC11	avI6/avC11_h2	   16.7893
Ri76	avC13_h30	avC13_h31	   11.5813
Ri77	avI6/avC11_h3	avI6/avC11_h4	   16.7360
Ri78	avI6/avC13	avI6/avC13_h2	   16.4800
Ri79	CLK_h36	CLK_h37	   11.7360
Ri80	avI6/avC13_h3	avI6/avC13_h4	   15.6453
Ri81	avI6/avC13_h4	avI6/avC13_h5	   15.0800
Ri82	GND_h23	GND_h24	   11.8907
Ri83	Q1_h1	Q1_h2	   11.5280
Ri84	avI6/avC13_h8	avI6/avC13_h6	   15.0800
Ri86	Q1_h4	Q1_h6	    1.6347
Ri87	Q1_h3	Q1_h4	   15.0000
Ri88	avI6/avC11_h5	avI6/avC11_h6	   11.4267
Ri89	RST_h21	RST_h22	   11.8373
Ri90	Q1_h9	Q1_h10	   15.4907
Ri91	Q1_h10	Q1_h11	   15.2347
Ri93	Q1_h15	Q1_h17	    2.2533
Ri94	Q1_h14	Q1_h15	   15.0000
Ri95	avC13_h34	avC13_h35	   11.5813
Ri96	Q1_h21	Q1_h20	   15.1280
Ri97	avI7/avC10	avI7/avC10_h2	   16.7893
Ri98	CLK_h39	CLK_h40	   11.7360
Ri99	avI7/avC10_h3	avI7/avC10_h4	   16.7360
Ri100	avI7/avC12	avI7/avC12_h2	   16.4800
Ri102	avC13_h37	avC13_h39	    1.5813
Ri103	avI7/avC12_h3	avI7/avC12_h4	   15.6453
Ri104	avI7/avC12_h4	avI7/avC12_h5	   15.0800
Ri106	RST_h25	RST_h27	    1.8373
Ri107	avI7/avC9	avI7/avC9_h2	   11.5280
Ri108	avI7/avC12_h8	avI7/avC12_h6	   15.0800
Ri109	avI7/avC9_h3	avI7/avC9_h4	   16.6347
Ri110	avI7/avC10_h5	avI7/avC10_h6	   11.4267
Ri112	GND_h28	GND_h30	    1.8907
Ri113	avI7/avC9_h7	avI7/avC9_h8	   15.4907
Ri114	avI7/avC9_h8	avI7/avC9_h9	   15.2347
Ri116	CLK_h45	CLK_h47	    1.7360
Ri117	avI7/avC11	avI7/avC11_h2	   16.7893
Ri118	avC13_h43	avC13_h44	   11.5813
Ri119	avI7/avC11_h3	avI7/avC11_h4	   16.7360
Ri120	avI7/avC13	avI7/avC13_h2	   16.4800
Ri121	CLK_h49	CLK_h50	   11.7360
Ri122	avI7/avC13_h3	avI7/avC13_h4	   15.6453
Ri123	avI7/avC13_h4	avI7/avC13_h5	   15.0800
Ri124	GND_h38	GND_h39	   11.8907
Ri125	Q2_h1	Q2_h2	   11.5280
Ri126	avI7/avC13_h8	avI7/avC13_h6	   15.0800
Ri128	Q2_h4	Q2_h6	    1.6347
Ri129	Q2_h3	Q2_h4	   15.0000
Ri130	avI7/avC11_h5	avI7/avC11_h6	   11.4267
Ri131	RST_h33	RST_h34	   11.8373
Ri132	Q2_h9	Q2_h10	   15.4907
Ri133	Q2_h10	Q2_h11	   15.2347
Ri135	Q2_h15	Q2_h17	    2.2533
Ri136	Q2_h14	Q2_h15	   15.0000
Ri137	avC13_h47	avC13_h48	   11.5813
Ri138	Q2_h21	Q2_h20	   15.1280
Ri139	avI8/avC10	avI8/avC10_h2	   16.7893
Ri140	CLK_h52	CLK_h53	   11.7360
Ri141	avI8/avC10_h3	avI8/avC10_h4	   16.7360
Ri142	avI8/avC12	avI8/avC12_h2	   16.4800
Ri144	avC13_h50	avC13_h52	    1.5813
Ri145	avI8/avC12_h3	avI8/avC12_h4	   15.6453
Ri146	avI8/avC12_h4	avI8/avC12_h5	   15.0800
Ri148	RST_h37	RST_h39	    1.8373
Ri149	avI8/avC9	avI8/avC9_h2	   11.5280
Ri150	avI8/avC12_h8	avI8/avC12_h6	   15.0800
Ri151	avI8/avC9_h3	avI8/avC9_h4	   16.6347
Ri152	avI8/avC10_h5	avI8/avC10_h6	   11.4267
Ri154	GND_h43	GND_h45	    1.8907
Ri155	avI8/avC9_h7	avI8/avC9_h8	   15.4907
Ri156	avI8/avC9_h8	avI8/avC9_h9	   15.2347
Ri158	CLK_h58	CLK_h60	    1.7360
Ri159	avI8/avC11	avI8/avC11_h2	   16.7893
Ri160	avC13_h56	avC13_h57	   11.5813
Ri161	avI8/avC11_h3	avI8/avC11_h4	   16.7360
Ri162	avI8/avC13	avI8/avC13_h2	   16.4800
Ri163	CLK_h62	CLK_h63	   11.7360
Ri164	avI8/avC13_h3	avI8/avC13_h4	   15.6453
Ri165	avI8/avC13_h4	avI8/avC13_h5	   15.0800
Ri166	GND_h53	GND_h54	   11.8907
Ri167	Q3_h1	Q3_h2	   11.5280
Ri168	avI8/avC13_h8	avI8/avC13_h6	   15.0800
Ri170	Q3_h4	Q3_h6	    1.6347
Ri171	Q3_h3	Q3_h4	   15.0000
Ri172	avI8/avC11_h5	avI8/avC11_h6	   11.4267
Ri173	RST_h45	RST_h46	   11.8373
Ri174	Q3_h9	Q3_h10	   15.4907
Ri175	Q3_h10	Q3_h11	   15.2347
Ri177	Q3_h15	Q3_h17	    2.2533
Ri178	Q3_h14	Q3_h15	   15.0000
Ri179	avC13_h60	avC13_h61	   11.5813
Ri180	Q3_h21	Q3_h20	   15.1280
Ri181	avI9/avC10	avI9/avC10_h2	   16.7893
Ri182	CLK_h65	CLK_h66	   11.7360
Ri183	avI9/avC10_h3	avI9/avC10_h4	   16.7360
Ri184	avI9/avC12	avI9/avC12_h2	   16.4800
Ri186	avC13_h63	avC13_h65	    1.5813
Ri187	avI9/avC12_h3	avI9/avC12_h4	   15.6453
Ri188	avI9/avC12_h4	avI9/avC12_h5	   15.0800
Ri190	RST_h49	RST_h51	    1.8373
Ri191	avI9/avC9	avI9/avC9_h2	   11.5280
Ri192	avI9/avC12_h8	avI9/avC12_h6	   15.0800
Ri193	avI9/avC9_h3	avI9/avC9_h4	   16.6347
Ri194	avI9/avC10_h5	avI9/avC10_h6	   11.4267
Ri196	GND_h58	GND_h60	    1.8907
Ri197	avI9/avC9_h7	avI9/avC9_h8	   15.4907
Ri198	avI9/avC9_h8	avI9/avC9_h9	   15.2347
Ri200	CLK_h71	CLK_h73	    1.7360
Ri201	avI9/avC11	avI9/avC11_h2	   16.7893
Ri202	avC13_h69	avC13_h70	   11.5813
Ri203	avI9/avC11_h3	avI9/avC11_h4	   16.7360
Ri204	avI9/avC13	avI9/avC13_h2	   16.4800
Ri205	CLK_h75	CLK_h76	   11.7360
Ri206	avI9/avC13_h3	avI9/avC13_h4	   15.6453
Ri207	avI9/avC13_h4	avI9/avC13_h5	   15.0800
Ri208	GND_h68	GND_h69	   11.8907
Ri209	Q4_h1	Q4_h2	   11.5280
Ri210	avI9/avC13_h8	avI9/avC13_h6	   15.0800
Ri212	Q4_h4	Q4_h6	    1.6347
Ri213	Q4_h3	Q4_h4	   15.0000
Ri214	avI9/avC11_h5	avI9/avC11_h6	   11.4267
Ri215	RST_h57	RST_h58	   11.8373
Ri216	Q4_h9	Q4_h10	   15.4907
Ri217	Q4_h10	Q4_h11	   15.2347
Ri219	Q4_h15	Q4_h17	    2.2533
Ri220	Q4_h14	Q4_h15	   15.0000
Ri221	avC13_h73	avC13_h74	   11.5813
Ri222	Q4_h21	Q4_h20	   15.1280
Ri223	avI10/avC10	avI10/avC10_h2	   16.7893
Ri224	CLK_h78	CLK_h79	   11.7360
Ri225	avI10/avC10_h3	avI10/avC10_h4	   16.7360
Ri226	avI10/avC12	avI10/avC12_h2	   16.4800
Ri228	avC13_h76	avC13_h78	    1.5813
Ri229	avI10/avC12_h3	avI10/avC12_h4	   15.6453
Ri230	avI10/avC12_h4	avI10/avC12_h5	   15.0800
Ri232	RST_h61	RST_h63	    1.8373
Ri233	avI10/avC9	avI10/avC9_h2	   11.5280
Ri234	avI10/avC12_h8	avI10/avC12_h6	   15.0800
Ri235	avI10/avC9_h3	avI10/avC9_h4	   16.6347
Ri236	avI10/avC10_h5	avI10/avC10_h6	   11.4267
Ri238	GND_h73	GND_h75	    1.8907
Ri239	avI10/avC9_h7	avI10/avC9_h8	   15.4907
Ri240	avI10/avC9_h8	avI10/avC9_h9	   15.2347
Ri242	CLK_h84	CLK_h86	    1.7360
Ri243	avI10/avC11	avI10/avC11_h2	   16.7893
Ri244	avC13_h82	avC13_h83	   11.5813
Ri245	avI10/avC11_h3	avI10/avC11_h4	   16.7360
Ri246	avI10/avC13	avI10/avC13_h2	   16.4800
Ri247	CLK_h88	CLK_h89	   11.7360
Ri248	avI10/avC13_h3	avI10/avC13_h4	   15.6453
Ri249	avI10/avC13_h4	avI10/avC13_h5	   15.0800
Ri250	GND_h83	GND_h84	   11.8907
Ri251	Q5_h1	Q5_h2	   11.5280
Ri252	avI10/avC13_h8	avI10/avC13_h6	   15.0800
Ri254	Q5_h4	Q5_h6	    1.6347
Ri255	Q5_h3	Q5_h4	   15.0000
Ri256	avI10/avC11_h5	avI10/avC11_h6	   11.4267
Ri257	RST_h69	RST_h70	   11.8373
Ri258	Q5_h9	Q5_h10	   15.4907
Ri259	Q5_h10	Q5_h11	   15.2347
Ri261	Q5_h15	Q5_h17	    2.2533
Ri262	Q5_h14	Q5_h15	   15.0000
Ri263	avC13_h86	avC13_h87	   11.5813
Ri264	Q5_h21	Q5_h20	   15.1280
Ri265	avI11/avC10	avI11/avC10_h2	   16.7893
Ri266	CLK_h91	CLK_h92	   11.7360
Ri267	avI11/avC10_h3	avI11/avC10_h4	   16.7360
Ri268	avI11/avC12	avI11/avC12_h2	   16.4800
Ri270	avC13_h89	avC13_h91	    1.5813
Ri271	avI11/avC12_h3	avI11/avC12_h4	   15.6453
Ri272	avI11/avC12_h4	avI11/avC12_h5	   15.0800
Ri274	RST_h73	RST_h75	    1.8373
Ri275	avI11/avC9	avI11/avC9_h2	   11.5280
Ri276	avI11/avC12_h8	avI11/avC12_h6	   15.0800
Ri277	avI11/avC9_h3	avI11/avC9_h4	   16.6347
Ri278	avI11/avC10_h5	avI11/avC10_h6	   11.4267
Ri280	GND_h88	GND_h90	    1.8907
Ri281	avI11/avC9_h7	avI11/avC9_h8	   15.4907
Ri282	avI11/avC9_h8	avI11/avC9_h9	   15.2347
Ri284	CLK_h97	CLK_h99	    1.7360
Ri285	avI11/avC11	avI11/avC11_h2	   16.7893
Ri286	avC13_h95	avC13_h96	   11.5813
Ri287	avI11/avC11_h3	avI11/avC11_h4	   16.7360
Ri288	avI11/avC13	avI11/avC13_h2	   16.4800
Ri289	CLK_h101	CLK_h102	   11.7360
Ri290	avI11/avC13_h3	avI11/avC13_h4	   15.6453
Ri291	avI11/avC13_h4	avI11/avC13_h5	   15.0800
Ri292	GND_h98	GND_h99	   11.8907
Ri293	Q6_h1	Q6_h2	   11.5280
Ri294	avI11/avC13_h8	avI11/avC13_h6	   15.0800
Ri296	Q6_h4	Q6_h6	    1.6347
Ri297	Q6_h3	Q6_h4	   15.0000
Ri298	avI11/avC11_h5	avI11/avC11_h6	   11.4267
Ri299	RST_h81	RST_h82	   11.8373
Ri300	Q6_h9	Q6_h10	   15.4907
Ri301	Q6_h10	Q6_h11	   15.2347
Ri303	Q6_h14	Q6_h16	    2.2533
Ri304	Q6_h13	Q6_h14	   15.0000
Ri305	avC13_h99	avC13_h100	   11.5813
Ri306	Q6_h21	Q6_h20	   15.1280
Ri307	avI12/avC10	avI12/avC10_h2	   16.7893
Ri308	CLK_h104	CLK_h105	   11.7360
Ri309	avI12/avC10_h3	avI12/avC10_h4	   16.7360
Ri310	avI12/avC12	avI12/avC12_h2	   16.4800
Ri312	avC13_h102	avC13_h104	    1.5813
Ri313	avI12/avC12_h3	avI12/avC12_h4	   15.6453
Ri314	avI12/avC12_h4	avI12/avC12_h5	   15.0800
Ri316	RST_h85	RST_h87	    1.8373
Ri317	avI12/avC9	avI12/avC9_h2	   11.5280
Ri318	avI12/avC12_h8	avI12/avC12_h6	   15.0800
Ri319	avI12/avC9_h3	avI12/avC9_h4	   16.6347
Ri320	avI12/avC10_h5	avI12/avC10_h6	   11.4267
Ri322	GND_h103	GND_h105	    1.8907
Ri323	avI12/avC9_h7	avI12/avC9_h8	   15.4907
Ri324	avI12/avC9_h8	avI12/avC9_h9	   15.2347
Ri326	CLK_h110	CLK_h112	    1.7360
Ri327	avI12/avC11	avI12/avC11_h2	   16.7893
Ri328	avC13_h108	avC13_h109	   11.5813
Ri329	avI12/avC11_h3	avI12/avC11_h4	   16.7360
Ri330	avI12/avC13	avI12/avC13_h2	   16.4800
Ri331	CLK_h114	CLK_h115	   11.7360
Ri332	avI12/avC13_h3	avI12/avC13_h4	   15.6453
Ri333	avI12/avC13_h4	avI12/avC13_h5	   15.0800
Ri334	GND_h113	GND_h114	   11.8907
Ri335	Q7_h1	Q7_h2	   11.5280
Ri336	avI12/avC13_h8	avI12/avC13_h6	   15.0800
Ri338	Q7_h4	Q7_h6	    1.6347
Ri339	Q7_h3	Q7_h4	   15.0000
Ri340	avI12/avC11_h5	avI12/avC11_h6	   11.4267
Ri341	RST_h93	RST_h94	   11.8373
Ri342	Q7_h9	Q7_h10	   15.4907
Ri343	Q7_h10	Q7_h11	   15.2347
Ri344	avI2/avC6	avI2/avC6_h2	   17.0453
Ri345	Q0_h22	Q0_h23	6.133E-02
Ri346	Q0_h23	Q0_h24	    1.6747
Ri347	Q5_h22	Q5_h23	   16.6347
Ri348	avI2/avC6_h3	avI2/avC6_h4	   11.6827
Ri349	Q0_h26	Q0_h27	   16.4267
Ri350	avC15	avC15_h2	   16.7893
Ri351	Q5_h24	Q5_h25	   11.5280
Ri352	avC15_h3	avC15_h4	   15.3013
Ri353	avC15_h4	avC15_h5	    1.4347
Ri354	avI2/avC6_h6	avI2/avC6_h7	   16.4800
Ri355	Q0_h30	Q0_h31	   11.7360
Ri356	Q5_h28	Q5_h29	   15.3600
Ri357	Q5_h29	Q5_h30	    1.5307
Ri358	avI3/avC6	avI3/avC6_h2	   17.0453
Ri359	Q6_h22	Q6_h23	6.133E-02
Ri360	Q6_h23	Q6_h24	    1.6747
Ri361	Q7_h14	Q7_h15	   16.6347
Ri362	avI3/avC6_h3	avI3/avC6_h4	   11.6827
Ri363	Q6_h28	Q6_h29	   16.4267
Ri364	avC16	avC16_h2	   16.7893
Ri365	Q7_h16	Q7_h17	   11.5280
Ri366	avC16_h3	avC16_h4	   15.3013
Ri367	avC16_h4	avC16_h5	    1.4347
Ri368	avI3/avC6_h6	avI3/avC6_h7	   16.4800
Ri369	Q6_h30	Q6_h31	   11.7360
Ri370	Q7_h20	Q7_h21	   15.3600
Ri371	Q7_h21	Q7_h22	    1.5307
Ri372	avI4/avC6	avI4/avC6_h2	   16.8907
Ri373	avC16_h8	avC16_h9	   10.0267
Ri374	avC16_h9	avC16_h10	3.467E-02
Ri375	avI4/avC6_h3	avI4/avC6_h4	   16.6347
Ri376	avI4/avC10	avI4/avC10_h2	   16.4267
Ri377	avI4/avC6_h5	avI4/avC6_h6	   11.5280
Ri378	avC14_h9	avC14_h10	   17.0453
Ri379	avI4/avC7	avI4/avC7_h2	   11.5280
Ri380	avI4/avC10_h3	avI4/avC10_h4	   16.4267
Ri381	avC14_h11	avC14_h12	   15.0453
Ri382	avC14_h12	avC14_h13	    1.4347
Ri383	avC15_h8	avC15_h9	   11.5813
Ri384	avC16_h15	avC16_h16	   11.4267
Ri385	avI4/avC10_h5	avI4/avC10_h6	   15.0267
Ri386	avI4/avC7_h5	avI4/avC7_h6	   16.8907
Ri387	avC15_h12	avC15_h13	6.133E-02
Ri388	avC15_h13	avC15_h14	    1.5200
Ri389	avI4/avC7_h7	avI4/avC7_h8	   16.6347
Ri390	VDD_h1	VDD	   15.4290
Ri391	VDD_h3	VDD	   10.7280
Ri392	VDD_h4	VDD	    9.7200
Ri393	VDD_h5	VDD	    9.0000
Ri394	VDD_h6	VDD	    8.0280
Ri395	VDD_h7	VDD	    6.8400
Ri396	VDD_h8	VDD	    5.5800
Ri397	VDD_h9	VDD	    4.3920
Ri398	VDD_h10	VDD	    3.1320
Ri399	VDD_h11	VDD	    1.9440
Ri400	VDD_h12	VDD	    0.6840
Ri401	VDD	VDD_h13	    0.5040
Ri402	VDD	VDD_h14	    1.7640
Ri403	VDD	VDD_h15	    2.9520
Ri404	VDD	VDD_h16	    4.2120
Ri405	VDD	VDD_h17	    5.4000
Ri406	VDD	VDD_h18	    6.6600
Ri407	VDD	VDD_h19	    7.8480
Ri408	VDD	VDD_h20	    9.1080
Ri409	VDD	VDD_h21	   10.2960
Ri410	VDD	VDD_h22	   15.4290
Ri411	VDD	VDD_h23	   15.4290
Ri412	VDD	VDD_h24	   15.4290
Ri413	VDD	VDD_h25	   15.4290
Ri414	VDD	VDD_h26	   15.4290
Ri415	VDD	VDD_h27	   15.4290
Ri416	VDD	VDD_h28	   15.4290
Ri417	VDD	VDD_h29	   15.4290
Ri418	VDD	VDD_h30	   15.4290
Ri419	VDD	VDD_h31	   15.4290
Ri420	VDD	VDD_h32	   15.4290
Ri421	VDD	VDD_h33	   15.4290
Ri422	VDD	VDD_h34	   15.4290
Ri423	VDD	VDD_h35	   15.4290
Ri424	VDD	VDD_h36	   15.4290
Ri425	VDD	VDD_h37	   15.4290
Ri426	VDD	VDD_h38	   15.4290
Ri427	VDD	VDD_h39	   15.4290
Ri428	VDD	VDD_h40	   15.4290
Ri429	VDD	VDD_h41	   15.4290
Ri430	VDD	VDD_h42	   15.4290
Ri431	VDD	VDD_h43	   15.4290
Ri432	VDD	VDD_h44	   15.4290
Ri433	VDD	VDD_h45	   15.4290
Ri434	VDD	VDD_h46	   15.4290
Ri435	VDD	VDD_h47	   15.4290
Ri436	VDD	VDD_h48	   15.4290
Ri437	VDD	VDD_h49	   15.4290
Ri438	VDD	VDD_h50	   15.4290
Ri439	VDD	VDD_h51	   15.4290
Ri440	VDD	VDD_h52	   15.4290
Ri441	VDD	VDD_h53	   15.4290
Ri442	VDD	VDD_h54	   15.4290
Ri443	VDD	VDD_h55	   15.4290
Ri444	VDD	VDD_h56	   15.4290
Ri445	VDD	VDD_h57	   15.4290
Ri446	VDD_h21	VDD_h58	   15.4201
Ri447	VDD_h59	VDD	   11.1600
Ri448	VDD	VDD_h60	   15.3296
Ri449	VDD_h2	VDD_h3	    0.8824
Ri450	VDD_h2	VDD_h4	    1.6667
Ri451	VDD_h2	VDD_h5	    1.6667
Ri452	VDD_h2	VDD_h6	    0.9375
Ri453	VDD_h2	VDD_h7	    0.8824
Ri454	VDD_h2	VDD_h8	    0.9375
Ri455	VDD_h2	VDD_h9	    0.8824
Ri456	VDD_h2	VDD_h10	    0.9375
Ri457	VDD_h2	VDD_h11	    0.8824
Ri458	VDD_h2	VDD_h12	    0.9375
Ri459	VDD_h2	VDD_h13	    0.8824
Ri460	VDD_h2	VDD_h14	    0.9375
Ri461	VDD_h2	VDD_h15	    0.8824
Ri462	VDD_h2	VDD_h16	    0.9375
Ri463	VDD_h2	VDD_h17	    0.8824
Ri464	VDD_h2	VDD_h18	    0.9375
Ri465	VDD_h2	VDD_h19	    0.8824
Ri466	VDD_h2	VDD_h20	    0.9375
Ri467	VDD_h2	VDD_h21	    0.8824
Ri468	VDD_h2	VDD_h59	    3.0000
Ri469	GND_h118	GND	   15.3650
Ri470	GND_h120	GND	   10.7280
Ri471	GND_h121	GND	    9.7200
Ri472	GND_h122	GND	    9.0000
Ri473	GND_h123	GND	    8.0280
Ri474	GND_h111	GND	    7.7760
Ri475	GND_h124	GND	    6.8400
Ri476	GND_h125	GND	    5.5800
Ri477	GND_h96	GND	    5.3280
Ri478	GND_h126	GND	    4.3920
Ri479	GND_h127	GND	    3.1320
Ri480	GND_h81	GND	    2.8800
Ri481	GND_h128	GND	    1.9440
Ri482	GND_h129	GND	    0.6840
Ri483	GND_h66	GND	    0.4320
Ri484	GND	GND_h130	    0.5040
Ri485	GND	GND_h131	    1.7640
Ri486	GND	GND_h51	    2.0160
Ri487	GND	GND_h132	    2.9520
Ri488	GND	GND_h133	    4.2120
Ri489	GND	GND_h36	    4.4640
Ri490	GND	GND_h134	    5.4000
Ri491	GND	GND_h135	    6.6600
Ri492	GND	GND_h21	    6.9120
Ri493	GND	GND_h136	    7.8480
Ri494	GND	GND_h137	    9.1080
Ri495	GND	GND_h10	   10.0800
Ri496	GND	GND_h138	   10.2960
Ri497	GND	GND_h139	   15.3650
Ri498	GND	GND_h140	   15.3650
Ri499	GND	GND_h141	   15.3650
Ri500	GND	GND_h142	   15.3650
Ri501	GND	GND_h143	   15.3650
Ri502	GND	GND_h144	   15.3650
Ri503	GND	GND_h145	   15.3650
Ri504	GND	GND_h146	   15.3650
Ri505	GND	GND_h147	   15.3650
Ri506	GND	GND_h148	   15.3650
Ri507	GND	GND_h149	   15.3650
Ri508	GND	GND_h150	   15.3650
Ri509	GND	GND_h151	   15.3650
Ri510	GND	GND_h152	   15.3650
Ri511	GND	GND_h153	   15.3650
Ri512	GND	GND_h154	   15.3650
Ri513	GND	GND_h155	   15.3650
Ri514	GND	GND_h156	   15.3650
Ri515	GND	GND_h157	   15.3650
Ri516	GND	GND_h158	   15.3650
Ri517	GND_h130	GND_h159	   15.3268
Ri518	GND	GND_h160	   15.3650
Ri519	GND	GND_h161	   15.3650
Ri520	GND	GND_h162	   15.3650
Ri521	GND_h132	GND_h163	   15.3268
Ri522	GND	GND_h164	   15.3650
Ri523	GND	GND_h165	   15.3650
Ri524	GND	GND_h166	   15.3650
Ri525	GND_h134	GND_h167	   15.3268
Ri526	GND	GND_h168	   15.3650
Ri527	GND	GND_h169	   15.3650
Ri528	GND	GND_h170	   15.3650
Ri529	GND_h136	GND_h171	   15.3268
Ri530	GND	GND_h172	   15.3650
Ri531	GND	GND_h173	   15.3650
Ri532	GND	GND_h174	   15.3650
Ri533	GND_h138	GND_h175	   15.3026
Ri534	GND	GND_h176	   11.1600
Ri535	GND_h176	GND	    0.1412
Ri536	GND	GND_h177	   15.2656
Ri537	GND	GND_h178	   15.3650
Ri538	GND_h119	GND_h120	    0.8824
Ri539	GND_h119	GND_h121	    1.6667
Ri540	GND_h119	GND_h122	    1.6667
Ri541	GND_h119	GND_h123	    0.9375
Ri542	GND_h119	GND_h124	    0.8824
Ri543	GND_h119	GND_h125	    0.9375
Ri544	GND_h119	GND_h126	    0.8824
Ri545	GND_h119	GND_h127	    0.9375
Ri546	GND_h119	GND_h128	    0.8824
Ri547	GND_h119	GND_h129	    0.9375
Ri548	GND_h119	GND_h130	    0.8824
Ri549	GND_h119	GND_h131	    0.9375
Ri550	GND_h119	GND_h132	    0.8824
Ri551	GND_h119	GND_h133	    0.9375
Ri552	GND_h119	GND_h134	    0.8824
Ri553	GND_h119	GND_h135	    0.9375
Ri554	GND_h119	GND_h136	    0.8824
Ri555	GND_h119	GND_h137	    0.9375
Ri556	GND_h119	GND_h138	    0.8824
Ri557	GND_h119	GND_h176	    3.0000
Rh1	avC13_h6	avC13_h2	    2.8600
Rh2	CLK_h10	CLK_h3	    0.2160
Rh4	avC14_h7	avC14_h5	    1.5080
Rh5	avC14_h5	avC14_h4	    0.1080
Rh6	avI5/avC12_h7	avI5/avC12_h8	    0.4320
Rh7	avI5/avC12_h8	avI5/avC12_h2	    0.2160
Rh8	avI5/avC12_h4	avI5/avC12_h8	    1.4000
Rh9	avI5/avC10_h6	avI5/avC10_h4	    0.9720
Rh10	avI5/avC10_h4	avI5/avC10_h2	    0.2160
Rh11	avI5/avC9_h8	avI5/avC9_h4	    1.8320
Rh12	avI5/avC9_h4	avI5/avC9_h2	    0.3240
Rh13	avC13_h18	avC13_h13	    1.5120
Rh14	avC13_h13	avC13_h16	    0.2160
Rh15	avC13_h16	avC13_h9	    0.2160
Rh16	CLK_h24	CLK_h21	    0.4320
Rh17	CLK_h21	CLK_h18	    0.9720
Rh18	CLK_h18	CLK_h14	    0.5400
Rh19	RST_h8	RST_h9	    0.5400
Rh20	RST_h9	RST_h3	    0.3240
Rh21	avI5/avC13_h6	avI5/avC13_h7	    1.8320
Rh22	avI5/avC13_h7	avI5/avC13_h2	    0.2160
Rh23	avI5/avC13_h4	avI5/avC13_h7	    1.4000
Rh24	avI5/avC11_h6	avI5/avC11_h4	    0.9720
Rh25	avI5/avC11_h4	avI5/avC11_h2	    0.2160
Rh26	GND_h8	GND_h9	    2.1577
Rh27	GND_h9	GND_h3	    0.4297
Rh28	GND_h9	GND_h10	    1.5055
Rh29	Q0_h10	Q0_h6	    1.8320
Rh30	Q0_h6	Q0_h12	    0.1080
Rh31	Q0_h12	Q0_h2	    0.2160
Rh32	Q0_h20	Q0_h19	    1.5080
Rh33	Q0_h19	Q0_h16	    0.1080
Rh34	avI6/avC12_h6	avI6/avC12_h7	    1.8320
Rh35	avI6/avC12_h7	avI6/avC12_h2	    0.2160
Rh36	avI6/avC12_h4	avI6/avC12_h7	    1.4000
Rh37	avI6/avC10_h6	avI6/avC10_h4	    0.9720
Rh38	avI6/avC10_h4	avI6/avC10_h2	    0.2160
Rh39	avI6/avC9_h8	avI6/avC9_h4	    1.8320
Rh40	avI6/avC9_h4	avI6/avC9_h2	    0.3240
Rh41	avC13_h31	avC13_h26	    1.5120
Rh42	avC13_h26	avC13_h29	    0.2160
Rh43	avC13_h29	avC13_h22	    0.2160
Rh44	CLK_h37	CLK_h34	    0.4320
Rh45	CLK_h34	CLK_h31	    0.9720
Rh46	CLK_h31	CLK_h27	    0.5400
Rh47	GND_h21	GND_h22	    2.8000
Rh48	GND_h24	GND_h19	    0.5400
Rh49	GND_h19	GND_h15	    0.3240
Rh50	avI6/avC13_h6	avI6/avC13_h7	    1.8320
Rh51	avI6/avC13_h7	avI6/avC13_h2	    0.2160
Rh52	avI6/avC13_h4	avI6/avC13_h7	    1.4000
Rh53	avI6/avC11_h6	avI6/avC11_h4	    0.9720
Rh54	avI6/avC11_h4	avI6/avC11_h2	    0.2160
Rh55	RST_h22	RST_h20	    2.1600
Rh56	RST_h20	RST_h15	    0.4320
Rh57	Q1_h10	Q1_h6	    1.8320
Rh58	Q1_h6	Q1_h12	    0.1080
Rh59	Q1_h12	Q1_h2	    0.2160
Rh60	Q1_h20	Q1_h18	    1.5080
Rh61	Q1_h18	Q1_h17	    0.1080
Rh62	avI7/avC12_h6	avI7/avC12_h7	    1.8320
Rh63	avI7/avC12_h7	avI7/avC12_h2	    0.2160
Rh64	avI7/avC12_h4	avI7/avC12_h7	    1.4000
Rh65	avI7/avC10_h6	avI7/avC10_h4	    0.9720
Rh66	avI7/avC10_h4	avI7/avC10_h2	    0.2160
Rh67	avI7/avC9_h8	avI7/avC9_h4	    1.8320
Rh68	avI7/avC9_h4	avI7/avC9_h2	    0.3240
Rh69	avC13_h44	avC13_h39	    1.5120
Rh70	avC13_h39	avC13_h42	    0.2160
Rh71	avC13_h42	avC13_h35	    0.2160
Rh72	CLK_h50	CLK_h47	    0.4320
Rh73	CLK_h47	CLK_h44	    0.9720
Rh74	CLK_h44	CLK_h40	    0.5400
Rh75	GND_h36	GND_h37	    2.8000
Rh76	GND_h39	GND_h34	    0.5400
Rh77	GND_h34	GND_h30	    0.3240
Rh78	avI7/avC13_h6	avI7/avC13_h7	    1.8320
Rh79	avI7/avC13_h7	avI7/avC13_h2	    0.2160
Rh80	avI7/avC13_h4	avI7/avC13_h7	    1.4000
Rh81	avI7/avC11_h6	avI7/avC11_h4	    0.9720
Rh82	avI7/avC11_h4	avI7/avC11_h2	    0.2160
Rh83	RST_h34	RST_h32	    2.1600
Rh84	RST_h32	RST_h27	    0.4320
Rh85	Q2_h10	Q2_h6	    1.8320
Rh86	Q2_h6	Q2_h12	    0.1080
Rh87	Q2_h12	Q2_h2	    0.2160
Rh88	Q2_h20	Q2_h18	    1.5080
Rh89	Q2_h18	Q2_h17	    0.1080
Rh90	avI8/avC12_h6	avI8/avC12_h7	    1.8320
Rh91	avI8/avC12_h7	avI8/avC12_h2	    0.2160
Rh92	avI8/avC12_h4	avI8/avC12_h7	    1.4000
Rh93	avI8/avC10_h6	avI8/avC10_h4	    0.9720
Rh94	avI8/avC10_h4	avI8/avC10_h2	    0.2160
Rh95	avI8/avC9_h8	avI8/avC9_h4	    1.8320
Rh96	avI8/avC9_h4	avI8/avC9_h2	    0.3240
Rh97	avC13_h57	avC13_h52	    1.5120
Rh98	avC13_h52	avC13_h55	    0.2160
Rh99	avC13_h55	avC13_h48	    0.2160
Rh100	CLK_h63	CLK_h60	    0.4320
Rh101	CLK_h60	CLK_h57	    0.9720
Rh102	CLK_h57	CLK_h53	    0.5400
Rh103	GND_h51	GND_h52	    2.8000
Rh104	GND_h54	GND_h49	    0.5400
Rh105	GND_h49	GND_h45	    0.3240
Rh106	avI8/avC13_h6	avI8/avC13_h7	    1.8320
Rh107	avI8/avC13_h7	avI8/avC13_h2	    0.2160
Rh108	avI8/avC13_h4	avI8/avC13_h7	    1.4000
Rh109	avI8/avC11_h6	avI8/avC11_h4	    0.9720
Rh110	avI8/avC11_h4	avI8/avC11_h2	    0.2160
Rh111	RST_h46	RST_h44	    2.1600
Rh112	RST_h44	RST_h39	    0.4320
Rh113	Q3_h10	Q3_h6	    1.8320
Rh114	Q3_h6	Q3_h12	    0.1080
Rh115	Q3_h12	Q3_h2	    0.2160
Rh116	Q3_h20	Q3_h18	    1.5080
Rh117	Q3_h18	Q3_h17	    0.1080
Rh118	avI9/avC12_h6	avI9/avC12_h7	    1.8320
Rh119	avI9/avC12_h7	avI9/avC12_h2	    0.2160
Rh120	avI9/avC12_h4	avI9/avC12_h7	    1.4000
Rh121	avI9/avC10_h6	avI9/avC10_h4	    0.9720
Rh122	avI9/avC10_h4	avI9/avC10_h2	    0.2160
Rh123	avI9/avC9_h8	avI9/avC9_h4	    1.8320
Rh124	avI9/avC9_h4	avI9/avC9_h2	    0.3240
Rh125	avC13_h70	avC13_h65	    1.5120
Rh126	avC13_h65	avC13_h68	    0.2160
Rh127	avC13_h68	avC13_h61	    0.2160
Rh128	CLK_h76	CLK_h73	    0.4320
Rh129	CLK_h73	CLK_h70	    0.9720
Rh130	CLK_h70	CLK_h66	    0.5400
Rh131	GND_h66	GND_h67	    2.8000
Rh132	GND_h69	GND_h64	    0.5400
Rh133	GND_h64	GND_h60	    0.3240
Rh134	avI9/avC13_h6	avI9/avC13_h7	    1.8320
Rh135	avI9/avC13_h7	avI9/avC13_h2	    0.2160
Rh136	avI9/avC13_h4	avI9/avC13_h7	    1.4000
Rh137	avI9/avC11_h6	avI9/avC11_h4	    0.9720
Rh138	avI9/avC11_h4	avI9/avC11_h2	    0.2160
Rh139	RST_h58	RST_h56	    2.1600
Rh140	RST_h56	RST_h51	    0.4320
Rh141	Q4_h10	Q4_h6	    1.8320
Rh142	Q4_h6	Q4_h12	    0.1080
Rh143	Q4_h12	Q4_h2	    0.2160
Rh144	Q4_h20	Q4_h18	    1.5080
Rh145	Q4_h18	Q4_h17	    0.1080
Rh146	avI10/avC12_h6	avI10/avC12_h7	    1.8320
Rh147	avI10/avC12_h7	avI10/avC12_h2	    0.2160
Rh148	avI10/avC12_h4	avI10/avC12_h7	    1.4000
Rh149	avI10/avC10_h6	avI10/avC10_h4	    0.9720
Rh150	avI10/avC10_h4	avI10/avC10_h2	    0.2160
Rh151	avI10/avC9_h8	avI10/avC9_h4	    1.8320
Rh152	avI10/avC9_h4	avI10/avC9_h2	    0.3240
Rh153	avC13_h83	avC13_h78	    1.5120
Rh154	avC13_h78	avC13_h81	    0.2160
Rh155	avC13_h81	avC13_h74	    0.2160
Rh156	CLK_h89	CLK_h86	    0.4320
Rh157	CLK_h86	CLK_h83	    0.9720
Rh158	CLK_h83	CLK_h79	    0.5400
Rh159	GND_h81	GND_h82	    2.8000
Rh160	GND_h84	GND_h79	    0.5400
Rh161	GND_h79	GND_h75	    0.3240
Rh162	avI10/avC13_h6	avI10/avC13_h7	    1.8320
Rh163	avI10/avC13_h7	avI10/avC13_h2	    0.2160
Rh164	avI10/avC13_h4	avI10/avC13_h7	    1.4000
Rh165	avI10/avC11_h6	avI10/avC11_h4	    0.9720
Rh166	avI10/avC11_h4	avI10/avC11_h2	    0.2160
Rh167	RST_h70	RST_h68	    2.1600
Rh168	RST_h68	RST_h63	    0.4320
Rh169	Q5_h10	Q5_h6	    1.8320
Rh170	Q5_h6	Q5_h12	    0.1080
Rh171	Q5_h12	Q5_h2	    0.2160
Rh172	Q5_h20	Q5_h18	    1.5080
Rh173	Q5_h18	Q5_h17	    0.1080
Rh174	avI11/avC12_h6	avI11/avC12_h7	    1.8320
Rh175	avI11/avC12_h7	avI11/avC12_h2	    0.2160
Rh176	avI11/avC12_h4	avI11/avC12_h7	    1.4000
Rh177	avI11/avC10_h6	avI11/avC10_h4	    0.9720
Rh178	avI11/avC10_h4	avI11/avC10_h2	    0.2160
Rh179	avI11/avC9_h8	avI11/avC9_h4	    1.8320
Rh180	avI11/avC9_h4	avI11/avC9_h2	    0.3240
Rh181	avC13_h96	avC13_h91	    1.5120
Rh182	avC13_h91	avC13_h94	    0.2160
Rh183	avC13_h94	avC13_h87	    0.2160
Rh184	CLK_h102	CLK_h99	    0.4320
Rh185	CLK_h99	CLK_h96	    0.9720
Rh186	CLK_h96	CLK_h92	    0.5400
Rh187	GND_h96	GND_h97	    2.8000
Rh188	GND_h99	GND_h94	    0.5400
Rh189	GND_h94	GND_h90	    0.3240
Rh190	avI11/avC13_h6	avI11/avC13_h7	    1.8320
Rh191	avI11/avC13_h7	avI11/avC13_h2	    0.2160
Rh192	avI11/avC13_h4	avI11/avC13_h7	    1.4000
Rh193	avI11/avC11_h6	avI11/avC11_h4	    0.9720
Rh194	avI11/avC11_h4	avI11/avC11_h2	    0.2160
Rh195	RST_h82	RST_h80	    2.1600
Rh196	RST_h80	RST_h75	    0.4320
Rh197	Q6_h10	Q6_h6	    1.8320
Rh198	Q6_h6	Q6_h12	    0.1080
Rh199	Q6_h12	Q6_h2	    0.2160
Rh200	Q6_h20	Q6_h19	    1.5080
Rh201	Q6_h19	Q6_h16	    0.1080
Rh202	avI12/avC12_h6	avI12/avC12_h7	    1.8320
Rh203	avI12/avC12_h7	avI12/avC12_h2	    0.2160
Rh204	avI12/avC12_h4	avI12/avC12_h7	    1.4000
Rh205	avI12/avC10_h6	avI12/avC10_h4	    0.9720
Rh206	avI12/avC10_h4	avI12/avC10_h2	    0.2160
Rh207	avI12/avC9_h8	avI12/avC9_h4	    1.8320
Rh208	avI12/avC9_h4	avI12/avC9_h2	    0.3240
Rh209	avC13_h109	avC13_h104	    1.5120
Rh210	avC13_h104	avC13_h107	    0.2160
Rh211	avC13_h107	avC13_h100	    0.2160
Rh212	CLK_h115	CLK_h112	    0.4320
Rh213	CLK_h112	CLK_h109	    0.9720
Rh214	CLK_h109	CLK_h105	    0.5400
Rh215	GND_h111	GND_h112	    2.8000
Rh216	GND_h114	GND_h109	    0.5400
Rh217	GND_h109	GND_h105	    0.3240
Rh218	avI12/avC13_h6	avI12/avC13_h7	    1.8320
Rh219	avI12/avC13_h7	avI12/avC13_h2	    0.2160
Rh220	avI12/avC13_h4	avI12/avC13_h7	    1.4000
Rh221	avI12/avC11_h6	avI12/avC11_h4	    0.9720
Rh222	avI12/avC11_h4	avI12/avC11_h2	    0.2160
Rh223	RST_h94	RST_h92	    2.1600
Rh224	RST_h92	RST_h87	    0.4320
Rh225	Q7_h10	Q7_h6	    1.8320
Rh226	Q7_h6	Q7_h12	    0.1080
Rh227	Q7_h12	Q7_h2	    0.2160
Rh228	avC15_h5	avC15_h6	    0.1080
Rh229	avC15_h6	avC15_h2	    0.1080
Rh230	avI2/avC6_h7	avI2/avC6_h4	    0.3240
Rh231	avI2/avC6_h4	avI2/avC6_h2	    0.3240
Rh232	Q0_h31	Q0_h26	    0.3240
Rh233	Q0_h26	Q0_h24	    0.3240
Rh236	Q5_h30	Q5_h25	    0.3240
Rh237	Q5_h25	Q5_h23	    0.3240
Rh238	avC16_h5	avC16_h6	    0.1080
Rh239	avC16_h6	avC16_h2	    0.1080
Rh240	avI3/avC6_h7	avI3/avC6_h4	    0.3240
Rh241	avI3/avC6_h4	avI3/avC6_h2	    0.3240
Rh242	Q6_h31	Q6_h28	    0.3240
Rh243	Q6_h28	Q6_h24	    0.3240
Rh246	Q7_h22	Q7_h17	    0.3240
Rh247	Q7_h17	Q7_h15	    0.3240
Rh248	avI4/avC6_h6	avI4/avC6_h4	    0.3240
Rh249	avI4/avC6_h4	avI4/avC6_h2	    0.2160
Rh250	avC14_h13	avC14_h14	    0.1080
Rh251	avC14_h14	avC14_h10	    0.1080
Rh252	avC16_h16	avC16_h13	    1.0800
Rh253	avC16_h13	avC16_h9	    1.4000
Rh254	avI4/avC10_h5	avI4/avC10_h3	    1.8320
Rh255	avI4/avC10_h3	avI4/avC10	    0.4320
Rh256	avC15_h14	avC15_h15	    0.2160
Rh257	avC15_h15	avC15_h9	    0.4320
Rh258	avI4/avC7_h8	avI4/avC7_h6	    0.2160
Rh259	avI4/avC7_h6	avI4/avC7_h2	    0.7560
Rg1	CLK_h4	CLK_h3	    3.3320
Rg2	avC13_h7	avC13_h6	    1.7000
Rg3	avC14_h5	avC14_h6	    3.1960
Rg4	avC13_h15	avC13_h16	    2.8480
Rg5	CLK_h17	CLK_h18	    2.8480
Rg6	RST_h9	RST_h12	    3.4280
Rg7	Q0_h17	Q0_h12	    3.2160
Rg8	Q0_h18	Q0_h19	    2.8480
Rg9	avC13_h28	avC13_h29	    2.8480
Rg10	CLK_h30	CLK_h31	    2.8480
Rg11	RST_h19	RST_h20	    2.8680
Rg12	GND_h19	GND_h20	    3.3120
Rg13	GND_h27	GND_h22	    1.7360
Rg14	Q1_h13	Q1_h12	    2.8480
Rg15	Q1_h18	Q1_h19	    3.3120
Rg16	avC13_h41	avC13_h42	    2.8480
Rg17	CLK_h43	CLK_h44	    2.8480
Rg18	RST_h31	RST_h32	    2.8680
Rg19	GND_h34	GND_h35	    3.3120
Rg20	GND_h42	GND_h37	    1.7360
Rg21	Q2_h13	Q2_h12	    2.8480
Rg22	Q2_h18	Q2_h19	    3.3120
Rg23	avC13_h54	avC13_h55	    2.8480
Rg24	CLK_h56	CLK_h57	    2.8480
Rg25	RST_h43	RST_h44	    2.8680
Rg26	GND_h49	GND_h50	    3.3120
Rg27	GND_h57	GND_h52	    1.7360
Rg28	Q3_h13	Q3_h12	    2.8480
Rg29	Q3_h18	Q3_h19	    3.3120
Rg30	avC13_h67	avC13_h68	    2.8480
Rg31	CLK_h69	CLK_h70	    2.8480
Rg32	RST_h55	RST_h56	    2.8680
Rg33	GND_h64	GND_h65	    3.3120
Rg34	GND_h72	GND_h67	    1.7360
Rg35	Q4_h13	Q4_h12	    2.8480
Rg36	Q4_h18	Q4_h19	    3.3120
Rg37	avC13_h80	avC13_h81	    2.8480
Rg38	CLK_h82	CLK_h83	    2.8480
Rg39	RST_h67	RST_h68	    2.8680
Rg40	GND_h79	GND_h80	    3.3120
Rg41	GND_h87	GND_h82	    1.7360
Rg42	Q5_h13	Q5_h12	    2.8480
Rg43	Q5_h18	Q5_h19	    3.3120
Rg44	avC13_h93	avC13_h94	    2.8480
Rg45	CLK_h95	CLK_h96	    2.8480
Rg46	RST_h79	RST_h80	    2.8680
Rg47	GND_h94	GND_h95	    3.5440
Rg48	GND_h102	GND_h97	    1.5040
Rg49	Q6_h17	Q6_h12	    3.3320
Rg50	Q6_h18	Q6_h19	    2.8680
Rg51	avC13_h106	avC13_h107	    2.8480
Rg52	CLK_h108	CLK_h109	    2.8480
Rg53	RST_h91	RST_h92	    2.8680
Rg54	GND_h109	GND_h110	    3.0800
Rg55	GND_h117	GND_h112	    1.9680
Rg56	Q7_h12	Q7_h13	    2.9640
Rg57	Q0_h28	Q0_h24	    2.8680
Rg58	avC15_h7	avC15_h6	    2.8680
Rg59	Q5_h32	Q5_h30	    2.8480
Rg60	Q6_h26	Q6_h24	    2.9840
Rg61	avC16_h6	avC16_h7	    2.9640
Rg62	Q7_h22	Q7_h24	    2.9640
Rg63	avC16_h13	avC16_h14	    2.9640
Rg64	avC14_h15	avC14_h14	    2.9840
Rg65	avC15_h19	avC15_h15	    2.8480
Rf1	GND_h27	GND_h20	    0.3240
Rf2	Q1_h19	Q1	    0.4318
Rf3	Q1	Q1_h13	    0.4320
Rf4	GND_h42	GND_h35	    0.3240
Rf5	Q2_h19	Q2	    0.4318
Rf6	Q2	Q2_h13	    0.4320
Rf7	GND_h57	GND_h50	    0.3240
Rf8	Q3_h19	Q3	    0.4318
Rf9	Q3	Q3_h13	    0.4320
Rf10	GND_h72	GND_h65	    0.3240
Rf11	Q4_h19	Q4	    0.4318
Rf12	Q4	Q4_h13	    0.4320
Rf13	GND_h87	GND_h80	    0.3240
Rf14	GND_h102	GND_h95	    0.3240
Rf15	avC13_h106	avC13_h93	    3.6720
Rf16	avC13_h93	avC13_h80	    3.6720
Rf17	avC13_h80	avC13_h67	    3.6720
Rf18	avC13_h67	avC13_h54	    3.6720
Rf19	avC13_h54	avC13_h41	    3.6720
Rf20	avC13_h41	avC13_h28	    3.6720
Rf21	avC13_h28	avC13_h15	    3.6720
Rf22	avC13_h15	avC13_h7	    0.6960
Rf23	CLK_h108	CLK_h95	    3.6720
Rf24	CLK_h95	CLK_h82	    3.6720
Rf25	CLK_h82	CLK_h69	    3.6720
Rf26	CLK_h69	CLK	    2.5378
Rf27	CLK	CLK_h56	    1.1340
Rf28	CLK_h56	CLK_h43	    3.6720
Rf29	CLK_h43	CLK_h30	    3.6720
Rf30	CLK_h30	CLK_h17	    3.6720
Rf31	CLK_h17	CLK_h4	    1.4040
Rf32	RST_h91	RST_h79	    3.6720
Rf33	RST_h79	RST_h67	    3.6720
Rf34	RST_h67	RST_h55	    3.6720
Rf35	RST_h55	RST	    1.4578
Rf36	RST	RST_h43	    2.2140
Rf37	RST_h43	RST_h31	    3.6720
Rf38	RST_h31	RST_h19	    3.6720
Rf39	RST_h19	RST_h12	    2.9160
Rf40	GND_h117	GND_h110	    0.3240
Rf41	Q0_h28	Q0	   13.2838
Rf42	Q0	Q0_h18	   12.4200
Rf43	Q0_h18	Q0_h17	    0.8640
Rf44	Q5_h32	Q5	    4.4818
Rf45	Q5	Q5_h19	    3.6180
Rf46	Q5_h19	Q5_h13	    0.8640
Rf47	Q6_h26	Q6	    2.8078
Rf48	Q6	Q6_h18	    1.9440
Rf49	Q6_h18	Q6_h17	    0.8640
Rf50	Q7_h24	Q7	    1.3498
Rf51	Q7	Q7_h13	    1.3500
Rf52	avC16_h14	avC16_h7	    0.6480
Rf53	avC14_h15	avC14_h6	   32.1840
Rf54	avC15_h19	avC15_h7	    3.0240
C1	VDD	GND	4.086E-15
C2	CLK	GND	9.104E-16
C3	Q0	GND	4.302E-15
C4	Q1	GND	2.105E-16
C5	Q2	GND	2.105E-16
C6	Q3	GND	2.105E-16
C7	Q4	GND	2.105E-16
C8	Q5	GND	1.879E-15
C9	Q6	GND	7.913E-16
C10	Q7	GND	3.990E-16
C11	RST	GND	4.791E-16
C12	avC13	GND	1.294E-16
C13	avC15	GND	1.016E-16
C14	avC16	GND	1.043E-16
C15	avC14	GND	1.158E-18
C16	avI12/avC17	GND	5.511E-18
C17	avI12/avC16	GND	9.037E-18
C18	avI12/avC15	GND	1.563E-17
C19	avI12/avC14	GND	8.502E-18
C20	avI12/avC13	GND	5.299E-17
C21	avI12/avC12	GND	4.721E-17
C22	avI12/avC11	GND	7.458E-17
C23	avI12/avC10	GND	8.145E-17
C24	avI12/avC9	GND	9.494E-17
C25	avI11/avC17	GND	5.863E-18
C26	avI11/avC16	GND	2.055E-17
C27	avI11/avC15	GND	1.916E-17
C28	avI11/avC14	GND	1.599E-17
C29	avI11/avC13	GND	4.054E-17
C30	avI11/avC12	GND	4.721E-17
C31	avI11/avC11	GND	7.306E-17
C32	avI11/avC10	GND	8.286E-17
C33	avI11/avC9	GND	9.308E-17
C34	avI10/avC17	GND	1.825E-17
C35	avI10/avC16	GND	2.055E-17
C36	avI10/avC15	GND	1.916E-17
C37	avI10/avC14	GND	1.664E-17
C38	avI10/avC13	GND	4.291E-17
C39	avI10/avC12	GND	4.683E-17
C40	avI10/avC11	GND	7.924E-17
C41	avI10/avC10	GND	8.169E-17
C42	avI10/avC9	GND	9.338E-17
C43	avI9/avC17	GND	1.825E-17
C44	avI9/avC16	GND	2.055E-17
C45	avI9/avC15	GND	1.916E-17
C46	avI9/avC14	GND	1.664E-17
C47	avI9/avC13	GND	4.291E-17
C48	avI9/avC12	GND	4.682E-17
C49	avI9/avC11	GND	7.924E-17
C50	avI9/avC10	GND	8.169E-17
C51	avI9/avC9	GND	9.338E-17
C52	avI8/avC17	GND	1.823E-17
C53	avI8/avC16	GND	2.055E-17
C54	avI8/avC15	GND	1.894E-17
C55	avI8/avC14	GND	1.664E-17
C56	avI8/avC13	GND	4.291E-17
C57	avI8/avC12	GND	4.683E-17
C58	avI8/avC11	GND	7.924E-17
C59	avI8/avC10	GND	8.169E-17
C60	avI8/avC9	GND	9.338E-17
C61	avI7/avC17	GND	1.825E-17
C62	avI7/avC16	GND	2.030E-17
C63	avI7/avC15	GND	1.916E-17
C64	avI7/avC14	GND	1.664E-17
C65	avI7/avC13	GND	4.291E-17
C66	avI7/avC12	GND	4.683E-17
C67	avI7/avC11	GND	7.924E-17
C68	avI7/avC10	GND	8.169E-17
C69	avI7/avC9	GND	9.338E-17
C70	avI6/avC17	GND	1.825E-17
C71	avI6/avC16	GND	2.055E-17
C72	avI6/avC15	GND	1.916E-17
C73	avI6/avC14	GND	1.664E-17
C74	avI6/avC13	GND	4.291E-17
C75	avI6/avC12	GND	4.683E-17
C76	avI6/avC11	GND	7.924E-17
C77	avI6/avC10	GND	7.981E-17
C78	avI6/avC9	GND	9.307E-17
C79	avI5/avC17	GND	1.825E-17
C80	avI5/avC16	GND	1.520E-17
C81	avI5/avC15	GND	1.081E-17
C82	avI5/avC14	GND	8.347E-18
C83	avI5/avC13	GND	4.482E-17
C84	avI5/avC12	GND	4.049E-17
C85	avI5/avC11	GND	7.463E-17
C86	avI5/avC10	GND	6.965E-17
C87	avI5/avC9	GND	9.310E-17
C88	avI4/avC10	GND	1.272E-16
C89	avI4/avC8	GND	1.934E-17
C90	avI4/avC7	GND	1.055E-16
C91	avI4/avC6	GND	8.393E-17
C92	avI3/avC6	GND	1.333E-16
C93	avI2/avC6	GND	1.354E-16
C94	CLK_h6	GND	4.598E-17
C95	CLK_h11	GND	4.772E-17
C96	CLK_h15	GND	5.549E-17
C97	avC13_h14	GND	5.845E-17
C98	avI5/avC9_h5	GND	6.222E-17
C99	avI5/avC10_h7	GND	5.866E-17
C100	RST_h4	GND	4.000E-17
C101	avC13_h19	GND	5.293E-17
C102	CLK_h25	GND	5.491E-17
C103	RST_h10	GND	4.192E-17
C104	Q0_h7	GND	5.670E-17
C105	avI5/avC11_h7	GND	6.322E-17
C106	CLK_h28	GND	5.098E-17
C107	avC13_h27	GND	5.865E-17
C108	RST_h16	GND	5.588E-17
C109	avI6/avC9_h5	GND	6.186E-17
C110	avI6/avC10_h7	GND	5.853E-17
C111	avC13_h32	GND	5.122E-17
C112	CLK_h38	GND	5.320E-17
C113	Q1_h7	GND	5.891E-17
C114	avI6/avC11_h7	GND	6.446E-17
C115	RST_h23	GND	6.185E-17
C116	CLK_h41	GND	5.548E-17
C117	avC13_h40	GND	5.865E-17
C118	RST_h28	GND	5.588E-17
C119	avI7/avC9_h5	GND	6.186E-17
C120	avI7/avC10_h7	GND	5.853E-17
C121	avC13_h45	GND	5.122E-17
C122	CLK_h51	GND	5.320E-17
C123	Q2_h7	GND	5.895E-17
C124	avI7/avC11_h7	GND	6.446E-17
C125	RST_h35	GND	6.185E-17
C126	CLK_h54	GND	5.548E-17
C127	avC13_h53	GND	5.865E-17
C128	RST_h40	GND	5.588E-17
C129	avI8/avC9_h5	GND	6.186E-17
C130	avI8/avC10_h7	GND	5.854E-17
C131	avC13_h58	GND	5.122E-17
C132	CLK_h64	GND	5.320E-17
C133	Q3_h7	GND	5.893E-17
C134	avI8/avC11_h7	GND	6.446E-17
C135	RST_h47	GND	6.185E-17
C136	CLK_h67	GND	5.548E-17
C137	avC13_h66	GND	5.865E-17
C138	RST_h52	GND	5.588E-17
C139	avI9/avC9_h5	GND	6.186E-17
C140	avI9/avC10_h7	GND	5.853E-17
C141	avC13_h71	GND	5.122E-17
C142	CLK_h77	GND	5.320E-17
C143	Q4_h7	GND	5.891E-17
C144	avI9/avC11_h7	GND	6.446E-17
C145	RST_h59	GND	6.185E-17
C146	CLK_h80	GND	5.548E-17
C147	avC13_h79	GND	5.865E-17
C148	RST_h64	GND	5.588E-17
C149	avI10/avC9_h5	GND	6.186E-17
C150	avI10/avC10_h7	GND	5.853E-17
C151	avC13_h84	GND	5.122E-17
C152	CLK_h90	GND	5.320E-17
C153	Q5_h7	GND	5.891E-17
C154	avI10/avC11_h7	GND	6.446E-17
C155	RST_h71	GND	6.185E-17
C156	CLK_h93	GND	5.548E-17
C157	avC13_h92	GND	5.865E-17
C158	RST_h76	GND	5.564E-17
C159	avI11/avC9_h5	GND	6.186E-17
C160	avI11/avC10_h7	GND	5.853E-17
C161	avC13_h97	GND	5.122E-17
C162	CLK_h103	GND	5.494E-17
C163	Q6_h7	GND	5.711E-17
C164	avI11/avC11_h7	GND	6.406E-17
C165	RST_h83	GND	5.746E-17
C166	CLK_h106	GND	5.165E-17
C167	avC13_h105	GND	5.908E-17
C168	RST_h88	GND	5.661E-17
C169	avI12/avC9_h5	GND	6.461E-17
C170	avI12/avC10_h7	GND	6.202E-17
C171	avC13_h110	GND	5.103E-17
C172	CLK_h116	GND	5.323E-17
C173	Q7_h7	GND	6.242E-17
C174	avI12/avC11_h7	GND	6.382E-17
C175	RST_h95	GND	6.277E-17
C176	Q0_h25	GND	6.396E-17
C177	Q5_h26	GND	6.914E-17
C178	Q0_h32	GND	5.104E-17
C179	Q6_h25	GND	6.180E-17
C180	Q7_h18	GND	6.954E-17
C181	Q6_h32	GND	5.188E-17
C182	avC16_h11	GND	5.734E-17
C183	avI4/avC6_h7	GND	6.633E-17
C184	avI4/avC7_h3	GND	6.500E-17
C185	avC15_h10	GND	5.729E-17
C186	avC16_h17	GND	6.876E-17
C187	avC15_h16	GND	6.490E-17
C188	CLK_h8	GND	3.392E-17
C189	CLK_h12	GND	4.730E-17
C190	avC13_h10	GND	5.430E-17
C191	CLK_h16	GND	5.856E-17
C192	avI5/avC9_h6	GND	5.215E-17
C193	avI5/avC10_h8	GND	5.397E-17
C194	RST_h6	GND	5.816E-17
C195	CLK_h22	GND	5.795E-17
C196	avC13_h20	GND	6.055E-17
C197	RST_h11	GND	5.903E-17
C198	Q0_h8	GND	5.413E-17
C199	avI5/avC11_h8	GND	5.615E-17
C200	avC13_h23	GND	5.509E-17
C201	CLK_h29	GND	5.899E-17
C202	RST_h18	GND	5.944E-17
C203	avI6/avC9_h6	GND	5.362E-17
C204	avI6/avC10_h8	GND	5.629E-17
C205	CLK_h35	GND	5.873E-17
C206	avC13_h33	GND	5.620E-17
C207	Q1_h8	GND	5.413E-17
C208	avI6/avC11_h8	GND	5.782E-17
C209	RST_h24	GND	5.842E-17
C210	avC13_h36	GND	5.585E-17
C211	CLK_h42	GND	5.911E-17
C212	RST_h30	GND	5.944E-17
C213	avI7/avC9_h6	GND	5.502E-17
C214	avI7/avC10_h8	GND	5.629E-17
C215	CLK_h48	GND	5.873E-17
C216	avC13_h46	GND	5.620E-17
C217	Q2_h8	GND	5.413E-17
C218	avI7/avC11_h8	GND	5.782E-17
C219	RST_h36	GND	5.842E-17
C220	avC13_h49	GND	5.585E-17
C221	CLK_h55	GND	5.911E-17
C222	RST_h42	GND	5.944E-17
C223	avI8/avC9_h6	GND	5.502E-17
C224	avI8/avC10_h8	GND	5.629E-17
C225	CLK_h61	GND	5.873E-17
C226	avC13_h59	GND	5.620E-17
C227	Q3_h8	GND	5.413E-17
C228	avI8/avC11_h8	GND	5.782E-17
C229	RST_h48	GND	5.842E-17
C230	avC13_h62	GND	5.585E-17
C231	CLK_h68	GND	5.911E-17
C232	RST_h54	GND	5.944E-17
C233	avI9/avC9_h6	GND	5.502E-17
C234	avI9/avC10_h8	GND	5.629E-17
C235	CLK_h74	GND	5.873E-17
C236	avC13_h72	GND	5.620E-17
C237	Q4_h8	GND	5.413E-17
C238	avI9/avC11_h8	GND	5.782E-17
C239	RST_h60	GND	5.842E-17
C240	avC13_h75	GND	5.585E-17
C241	CLK_h81	GND	5.911E-17
C242	RST_h66	GND	5.944E-17
C243	avI10/avC9_h6	GND	5.502E-17
C244	avI10/avC10_h8	GND	5.629E-17
C245	CLK_h87	GND	5.873E-17
C246	avC13_h85	GND	5.620E-17
C247	Q5_h8	GND	5.413E-17
C248	avI10/avC11_h8	GND	5.784E-17
C249	RST_h72	GND	5.842E-17
C250	avC13_h88	GND	5.582E-17
C251	CLK_h94	GND	6.105E-17
C252	RST_h78	GND	5.936E-17
C253	avI11/avC9_h6	GND	5.440E-17
C254	avI11/avC10_h8	GND	5.798E-17
C255	CLK_h100	GND	6.064E-17
C256	avC13_h98	GND	5.394E-17
C257	Q6_h8	GND	5.537E-17
C258	avI11/avC11_h8	GND	5.785E-17
C259	RST_h84	GND	5.842E-17
C260	avC13_h101	GND	5.670E-17
C261	CLK_h107	GND	6.090E-17
C262	RST_h90	GND	5.936E-17
C263	avI12/avC9_h6	GND	5.440E-17
C264	avI12/avC10_h8	GND	5.655E-17
C265	CLK_h113	GND	6.075E-17
C266	avC13_h111	GND	5.763E-17
C267	Q7_h8	GND	5.487E-17
C268	avI12/avC11_h8	GND	6.058E-17
C269	RST_h96	GND	4.548E-17
C270	avI2/avC6_h5	GND	4.519E-17
C271	Q5_h27	GND	5.980E-17
C272	Q0_h33	GND	6.118E-17
C273	avI3/avC6_h5	GND	4.604E-17
C274	Q7_h19	GND	5.882E-17
C275	Q6_h33	GND	5.846E-17
C276	avC16_h12	GND	5.530E-17
C277	avI4/avC6_h8	GND	5.588E-17
C278	avI4/avC7_h4	GND	5.257E-17
C279	avC15_h11	GND	5.751E-17
C280	avC16_h18	GND	5.861E-17
C281	avC15_h18	GND	5.784E-17
C282	avC13_h6	GND	8.201E-17
C283	avC14_h5	GND	6.822E-17
C284	avC13_h16	GND	1.103E-16
C285	CLK_h18	GND	2.564E-16
C286	RST_h9	GND	2.253E-16
C287	Q0_h12	GND	1.259E-16
C288	Q0_h19	GND	2.235E-17
C289	avC13_h29	GND	1.099E-16
C290	CLK_h31	GND	2.580E-16
C291	RST_h20	GND	3.810E-16
C292	Q1_h12	GND	7.060E-17
C293	Q1_h18	GND	8.881E-17
C294	avC13_h42	GND	1.099E-16
C295	CLK_h44	GND	2.580E-16
C296	RST_h32	GND	3.810E-16
C297	Q2_h12	GND	7.060E-17
C298	Q2_h18	GND	8.881E-17
C299	avC13_h55	GND	1.099E-16
C300	CLK_h57	GND	2.580E-16
C301	RST_h44	GND	3.810E-16
C302	Q3_h12	GND	7.060E-17
C303	Q3_h18	GND	8.881E-17
C304	avC13_h68	GND	1.099E-16
C305	CLK_h70	GND	2.580E-16
C306	RST_h56	GND	3.810E-16
C307	Q4_h12	GND	7.060E-17
C308	Q4_h18	GND	8.881E-17
C309	avC13_h81	GND	1.099E-16
C310	CLK_h83	GND	2.580E-16
C311	RST_h68	GND	3.810E-16
C312	Q5_h12	GND	7.060E-17
C313	Q5_h18	GND	8.881E-17
C314	avC13_h94	GND	1.099E-16
C315	CLK_h96	GND	2.568E-16
C316	RST_h80	GND	3.869E-16
C317	Q6_h12	GND	1.410E-16
C318	Q6_h19	GND	5.584E-17
C319	avC13_h107	GND	1.104E-16
C320	CLK_h109	GND	2.702E-16
C321	RST_h92	GND	3.896E-16
C322	Q7_h12	GND	1.013E-16
C323	avC15_h6	GND	7.921E-17
C324	avC16_h6	GND	6.948E-17
C325	avC16_h13	GND	2.586E-16
C326	avC14_h14	GND	5.782E-17
C327	avC15_h15	GND	1.115E-16
C328	CLK_h1	GND	1.265E-16
C329	CLK_h9	GND	1.434E-16
C330	avC13_h8	GND	1.565E-16
C331	CLK_h13	GND	1.763E-16
C332	avC13_h11	GND	1.495E-16
C333	avI5/avC10_h5	GND	5.767E-17
C334	RST_h1	GND	1.952E-16
C335	CLK_h19	GND	1.994E-16
C336	avC13_h17	GND	1.520E-16
C337	CLK_h23	GND	1.728E-16
C338	RST_h7	GND	1.875E-16
C339	Q0_h1	GND	9.433E-17
C340	avI5/avC11_h5	GND	5.619E-17
C341	avC13_h21	GND	1.572E-16
C342	CLK_h26	GND	1.759E-16
C343	avC13_h24	GND	1.489E-16
C344	RST_h13	GND	1.824E-16
C345	avI6/avC10_h5	GND	5.703E-17
C346	CLK_h32	GND	1.978E-16
C347	avC13_h30	GND	1.519E-16
C348	CLK_h36	GND	1.735E-16
C349	Q1_h1	GND	9.642E-17
C350	avI6/avC11_h5	GND	5.685E-17
C351	RST_h21	GND	1.752E-16
C352	avC13_h34	GND	1.570E-16
C353	CLK_h39	GND	1.748E-16
C354	avC13_h37	GND	1.488E-16
C355	RST_h25	GND	1.827E-16
C356	avI7/avC10_h5	GND	5.703E-17
C357	CLK_h45	GND	1.978E-16
C358	avC13_h43	GND	1.519E-16
C359	CLK_h49	GND	1.735E-16
C360	Q2_h1	GND	9.642E-17
C361	avI7/avC11_h5	GND	5.685E-17
C362	RST_h33	GND	1.752E-16
C363	avC13_h47	GND	1.570E-16
C364	CLK_h52	GND	1.748E-16
C365	avC13_h50	GND	1.488E-16
C366	RST_h37	GND	1.827E-16
C367	avI8/avC10_h5	GND	5.703E-17
C368	CLK_h58	GND	1.978E-16
C369	avC13_h56	GND	1.519E-16
C370	CLK_h62	GND	1.735E-16
C371	Q3_h1	GND	9.642E-17
C372	avI8/avC11_h5	GND	5.685E-17
C373	RST_h45	GND	1.752E-16
C374	avC13_h60	GND	1.570E-16
C375	CLK_h65	GND	1.748E-16
C376	avC13_h63	GND	1.488E-16
C377	RST_h49	GND	1.827E-16
C378	avI9/avC10_h5	GND	5.703E-17
C379	CLK_h71	GND	1.978E-16
C380	avC13_h69	GND	1.519E-16
C381	CLK_h75	GND	1.735E-16
C382	Q4_h1	GND	9.642E-17
C383	avI9/avC11_h5	GND	5.685E-17
C384	RST_h57	GND	1.752E-16
C385	avC13_h73	GND	1.570E-16
C386	CLK_h78	GND	1.748E-16
C387	avC13_h76	GND	1.488E-16
C388	RST_h61	GND	1.827E-16
C389	avI10/avC10_h5	GND	5.703E-17
C390	CLK_h84	GND	1.978E-16
C391	avC13_h82	GND	1.519E-16
C392	CLK_h88	GND	1.735E-16
C393	Q5_h1	GND	9.642E-17
C394	avI10/avC11_h5	GND	5.685E-17
C395	RST_h69	GND	1.752E-16
C396	avC13_h86	GND	1.570E-16
C397	CLK_h91	GND	1.754E-16
C398	avC13_h89	GND	1.504E-16
C399	RST_h73	GND	1.824E-16
C400	avI11/avC10_h5	GND	5.753E-17
C401	CLK_h97	GND	1.983E-16
C402	avC13_h95	GND	1.527E-16
C403	CLK_h101	GND	1.746E-16
C404	Q6_h1	GND	9.586E-17
C405	avI11/avC11_h5	GND	5.670E-17
C406	RST_h81	GND	1.766E-16
C407	avC13_h99	GND	1.577E-16
C408	CLK_h104	GND	1.759E-16
C409	avC13_h102	GND	1.511E-16
C410	RST_h85	GND	1.859E-16
C411	avI12/avC10_h5	GND	5.836E-17
C412	CLK_h110	GND	1.949E-16
C413	avC13_h108	GND	1.521E-16
C414	CLK_h114	GND	1.702E-16
C415	Q7_h1	GND	9.770E-17
C416	avI12/avC11_h5	GND	5.999E-17
C417	RST_h93	GND	1.724E-16
C418	Q0_h22	GND	1.500E-16
C419	avI2/avC6_h3	GND	1.439E-16
C420	Q5_h24	GND	1.269E-16
C421	Q0_h30	GND	1.807E-16
C422	Q6_h22	GND	1.540E-16
C423	avI3/avC6_h3	GND	1.448E-16
C424	Q7_h16	GND	1.268E-16
C425	Q6_h30	GND	1.834E-16
C426	avC16_h8	GND	6.843E-17
C427	avI4/avC6_h5	GND	1.017E-16
C428	avC15_h8	GND	9.832E-17
C429	avC16_h15	GND	5.359E-17
C430	avC15_h12	GND	1.423E-16
C431	CLK_h4	GND	2.987E-16
C432	avC13_h7	GND	1.940E-16
C433	avC14_h6	GND	6.747E-15
C434	avC13_h15	GND	1.125E-15
C435	CLK_h17	GND	7.768E-16
C436	RST_h12	GND	3.860E-16
C437	Q0_h17	GND	2.267E-16
C438	Q0_h18	GND	2.216E-15
C439	avC13_h28	GND	1.893E-15
C440	CLK_h30	GND	1.869E-15
C441	RST_h19	GND	7.013E-16
C442	Q1_h13	GND	2.020E-16
C443	Q1_h19	GND	2.230E-16
C444	avC13_h41	GND	1.888E-15
C445	CLK_h43	GND	1.879E-15
C446	RST_h31	GND	8.870E-16
C447	Q2_h13	GND	2.020E-16
C448	Q2_h19	GND	2.230E-16
C449	avC13_h54	GND	1.888E-15
C450	CLK_h56	GND	1.252E-15
C451	RST_h43	GND	7.290E-16
C452	Q3_h13	GND	2.021E-16
C453	Q3_h19	GND	2.230E-16
C454	avC13_h67	GND	1.888E-15
C455	CLK_h69	GND	1.595E-15
C456	RST_h55	GND	5.658E-16
C457	Q4_h13	GND	2.020E-16
C458	Q4_h19	GND	2.230E-16
C459	avC13_h80	GND	1.888E-15
C460	CLK_h82	GND	1.879E-15
C461	RST_h67	GND	8.870E-16
C462	Q5_h13	GND	3.074E-16
C463	Q5_h19	GND	1.203E-15
C464	avC13_h93	GND	1.888E-15
C465	CLK_h95	GND	1.879E-15
C466	RST_h79	GND	1.292E-15
C467	Q6_h17	GND	2.420E-16
C468	Q6_h18	GND	4.804E-16
C469	avC13_h106	GND	1.029E-15
C470	CLK_h108	GND	9.529E-16
C471	RST_h91	GND	6.543E-16
C472	Q7_h13	GND	2.700E-16
C473	Q0_h28	GND	2.646E-15
C474	avC15_h7	GND	5.437E-16
C475	Q5_h32	GND	1.122E-15
C476	Q6_h26	GND	3.342E-16
C477	avC16_h7	GND	2.346E-16
C478	Q7_h24	GND	2.344E-16
C479	avC16_h14	GND	1.844E-16
C480	avC14_h15	GND	7.212E-15
C481	avC15_h19	GND	3.994E-16
C482	CLK_h3	GND	2.374E-16
C483	avC13_h2	GND	6.440E-17
C484	CLK_h10	GND	1.789E-16
C485	avC14_h4	GND	1.473E-16
C486	avC13_h9	GND	1.235E-16
C487	avI5/avC10_h2	GND	2.118E-16
C488	avC14_h7	GND	6.455E-17
C489	CLK_h14	GND	2.176E-16
C490	avI5/avC12_h2	GND	7.158E-17
C491	avI5/avC10_h4	GND	3.620E-16
C492	avC13_h13	GND	5.280E-16
C493	avI5/avC12_h4	GND	2.239E-16
C494	avI5/avC9_h2	GND	1.818E-16
C495	avI5/avC12_h7	GND	2.021E-16
C496	avI5/avC9_h4	GND	2.013E-16
C497	avI5/avC10_h6	GND	3.980E-16
C498	RST_h3	GND	1.734E-16
C499	avI5/avC9_h8	GND	2.264E-16
C500	CLK_h21	GND	4.054E-16
C501	avI5/avC11_h2	GND	2.120E-16
C502	avC13_h18	GND	4.674E-16
C503	avI5/avC13_h2	GND	1.110E-16
C504	avI5/avC11_h4	GND	2.799E-16
C505	CLK_h24	GND	2.272E-16
C506	avI5/avC13_h4	GND	2.330E-16
C507	RST_h8	GND	1.896E-16
C508	Q0_h2	GND	1.394E-16
C509	avI5/avC13_h6	GND	1.993E-16
C510	Q0_h6	GND	1.489E-16
C511	avI5/avC11_h6	GND	2.917E-16
C512	Q0_h10	GND	1.526E-16
C513	Q0_h16	GND	1.256E-16
C514	avC13_h22	GND	1.296E-16
C515	avI6/avC10_h2	GND	2.121E-16
C516	Q0_h20	GND	6.307E-17
C517	CLK_h27	GND	2.143E-16
C518	avI6/avC12_h2	GND	7.057E-17
C519	avI6/avC10_h4	GND	3.583E-16
C520	avC13_h26	GND	5.251E-16
C521	avI6/avC12_h4	GND	2.231E-16
C522	RST_h15	GND	2.253E-16
C523	avI6/avC9_h2	GND	1.773E-16
C524	avI6/avC12_h6	GND	2.137E-16
C525	avI6/avC9_h4	GND	1.942E-16
C526	avI6/avC10_h6	GND	3.906E-16
C527	avI6/avC9_h8	GND	2.208E-16
C528	CLK_h34	GND	4.070E-16
C529	avI6/avC11_h2	GND	2.118E-16
C530	avC13_h31	GND	4.624E-16
C531	avI6/avC13_h2	GND	1.097E-16
C532	avI6/avC11_h4	GND	2.771E-16
C533	CLK_h37	GND	2.249E-16
C534	avI6/avC13_h4	GND	2.345E-16
C535	Q1_h2	GND	1.397E-16
C536	avI6/avC13_h6	GND	2.093E-16
C537	Q1_h6	GND	1.485E-16
C538	avI6/avC11_h6	GND	2.884E-16
C539	RST_h22	GND	4.804E-16
C540	Q1_h10	GND	1.460E-16
C541	Q1_h17	GND	1.276E-16
C542	avC13_h35	GND	1.293E-16
C543	avI7/avC10_h2	GND	2.106E-16
C544	Q1_h20	GND	6.740E-17
C545	CLK_h40	GND	2.145E-16
C546	avI7/avC12_h2	GND	7.364E-17
C547	avI7/avC10_h4	GND	3.582E-16
C548	avC13_h39	GND	5.251E-16
C549	avI7/avC12_h4	GND	2.236E-16
C550	RST_h27	GND	2.254E-16
C551	avI7/avC9_h2	GND	1.802E-16
C552	avI7/avC12_h6	GND	2.137E-16
C553	avI7/avC9_h4	GND	1.942E-16
C554	avI7/avC10_h6	GND	3.906E-16
C555	avI7/avC9_h8	GND	2.208E-16
C556	CLK_h47	GND	4.070E-16
C557	avI7/avC11_h2	GND	2.118E-16
C558	avC13_h44	GND	4.624E-16
C559	avI7/avC13_h2	GND	1.097E-16
C560	avI7/avC11_h4	GND	2.771E-16
C561	CLK_h50	GND	2.249E-16
C562	avI7/avC13_h4	GND	2.345E-16
C563	Q2_h2	GND	1.397E-16
C564	avI7/avC13_h6	GND	2.093E-16
C565	Q2_h6	GND	1.485E-16
C566	avI7/avC11_h6	GND	2.884E-16
C567	RST_h34	GND	4.804E-16
C568	Q2_h10	GND	1.460E-16
C569	Q2_h17	GND	1.276E-16
C570	avC13_h48	GND	1.293E-16
C571	avI8/avC10_h2	GND	2.106E-16
C572	Q2_h20	GND	6.740E-17
C573	CLK_h53	GND	2.145E-16
C574	avI8/avC12_h2	GND	7.364E-17
C575	avI8/avC10_h4	GND	3.582E-16
C576	avC13_h52	GND	5.251E-16
C577	avI8/avC12_h4	GND	2.236E-16
C578	RST_h39	GND	2.254E-16
C579	avI8/avC9_h2	GND	1.802E-16
C580	avI8/avC12_h6	GND	2.137E-16
C581	avI8/avC9_h4	GND	1.942E-16
C582	avI8/avC10_h6	GND	3.906E-16
C583	avI8/avC9_h8	GND	2.208E-16
C584	CLK_h60	GND	4.069E-16
C585	avI8/avC11_h2	GND	2.118E-16
C586	avC13_h57	GND	4.623E-16
C587	avI8/avC13_h2	GND	1.097E-16
C588	avI8/avC11_h4	GND	2.771E-16
C589	CLK_h63	GND	2.249E-16
C590	avI8/avC13_h4	GND	2.345E-16
C591	Q3_h2	GND	1.397E-16
C592	avI8/avC13_h6	GND	2.093E-16
C593	Q3_h6	GND	1.485E-16
C594	avI8/avC11_h6	GND	2.884E-16
C595	RST_h46	GND	4.804E-16
C596	Q3_h10	GND	1.460E-16
C597	Q3_h17	GND	1.276E-16
C598	avC13_h61	GND	1.293E-16
C599	avI9/avC10_h2	GND	2.106E-16
C600	Q3_h20	GND	6.740E-17
C601	CLK_h66	GND	2.145E-16
C602	avI9/avC12_h2	GND	7.360E-17
C603	avI9/avC10_h4	GND	3.582E-16
C604	avC13_h65	GND	5.251E-16
C605	avI9/avC12_h4	GND	2.236E-16
C606	RST_h51	GND	2.254E-16
C607	avI9/avC9_h2	GND	1.802E-16
C608	avI9/avC12_h6	GND	2.137E-16
C609	avI9/avC9_h4	GND	1.942E-16
C610	avI9/avC10_h6	GND	3.900E-16
C611	avI9/avC9_h8	GND	2.208E-16
C612	CLK_h73	GND	4.070E-16
C613	avI9/avC11_h2	GND	2.118E-16
C614	avC13_h70	GND	4.624E-16
C615	avI9/avC13_h2	GND	1.097E-16
C616	avI9/avC11_h4	GND	2.771E-16
C617	CLK_h76	GND	2.249E-16
C618	avI9/avC13_h4	GND	2.345E-16
C619	Q4_h2	GND	1.397E-16
C620	avI9/avC13_h6	GND	2.093E-16
C621	Q4_h6	GND	1.485E-16
C622	avI9/avC11_h6	GND	2.884E-16
C623	RST_h58	GND	4.804E-16
C624	Q4_h10	GND	1.460E-16
C625	Q4_h17	GND	1.276E-16
C626	avC13_h74	GND	1.293E-16
C627	avI10/avC10_h2	GND	2.106E-16
C628	Q4_h20	GND	6.740E-17
C629	CLK_h79	GND	2.145E-16
C630	avI10/avC12_h2	GND	7.364E-17
C631	avI10/avC10_h4	GND	3.582E-16
C632	avC13_h78	GND	5.251E-16
C633	avI10/avC12_h4	GND	2.236E-16
C634	RST_h63	GND	2.254E-16
C635	avI10/avC9_h2	GND	1.802E-16
C636	avI10/avC12_h6	GND	2.137E-16
C637	avI10/avC9_h4	GND	1.942E-16
C638	avI10/avC10_h6	GND	3.906E-16
C639	avI10/avC9_h8	GND	2.208E-16
C640	CLK_h86	GND	4.070E-16
C641	avI10/avC11_h2	GND	2.118E-16
C642	avC13_h83	GND	4.624E-16
C643	avI10/avC13_h2	GND	1.097E-16
C644	avI10/avC11_h4	GND	2.771E-16
C645	CLK_h89	GND	2.249E-16
C646	avI10/avC13_h4	GND	2.345E-16
C647	Q5_h2	GND	1.397E-16
C648	avI10/avC13_h6	GND	2.093E-16
C649	Q5_h6	GND	1.485E-16
C650	avI10/avC11_h6	GND	2.884E-16
C651	RST_h70	GND	4.804E-16
C652	Q5_h10	GND	1.460E-16
C653	Q5_h17	GND	1.276E-16
C654	avC13_h87	GND	1.292E-16
C655	avI11/avC10_h2	GND	2.106E-16
C656	Q5_h20	GND	6.740E-17
C657	CLK_h92	GND	2.145E-16
C658	avI11/avC12_h2	GND	7.576E-17
C659	avI11/avC10_h4	GND	3.557E-16
C660	avC13_h91	GND	5.251E-16
C661	avI11/avC12_h4	GND	2.276E-16
C662	RST_h75	GND	2.260E-16
C663	avI11/avC9_h2	GND	1.811E-16
C664	avI11/avC12_h6	GND	2.160E-16
C665	avI11/avC9_h4	GND	1.992E-16
C666	avI11/avC10_h6	GND	3.900E-16
C667	avI11/avC9_h8	GND	2.256E-16
C668	CLK_h99	GND	4.070E-16
C669	avI11/avC11_h2	GND	2.108E-16
C670	avC13_h96	GND	4.618E-16
C671	avI11/avC13_h2	GND	1.128E-16
C672	avI11/avC11_h4	GND	2.787E-16
C673	CLK_h102	GND	2.269E-16
C674	avI11/avC13_h4	GND	2.383E-16
C675	Q6_h2	GND	1.440E-16
C676	avI11/avC13_h6	GND	2.014E-16
C677	Q6_h6	GND	1.539E-16
C678	avI11/avC11_h6	GND	2.955E-16
C679	RST_h82	GND	4.874E-16
C680	Q6_h10	GND	1.562E-16
C681	Q6_h16	GND	1.279E-16
C682	avC13_h100	GND	1.280E-16
C683	avI12/avC10_h2	GND	2.121E-16
C684	Q6_h20	GND	6.002E-17
C685	CLK_h105	GND	2.082E-16
C686	avI12/avC12_h2	GND	7.292E-17
C687	avI12/avC10_h4	GND	3.622E-16
C688	avC13_h104	GND	5.378E-16
C689	avI12/avC12_h4	GND	2.274E-16
C690	RST_h87	GND	2.259E-16
C691	avI12/avC9_h2	GND	1.773E-16
C692	avI12/avC12_h6	GND	2.150E-16
C693	avI12/avC9_h4	GND	1.974E-16
C694	avI12/avC10_h6	GND	3.971E-16
C695	avI12/avC9_h8	GND	2.211E-16
C696	CLK_h112	GND	4.174E-16
C697	avI12/avC11_h2	GND	2.122E-16
C698	avC13_h109	GND	4.780E-16
C699	avI12/avC13_h2	GND	1.057E-16
C700	avI12/avC11_h4	GND	2.837E-16
C701	CLK_h115	GND	2.270E-16
C702	avI12/avC13_h4	GND	2.353E-16
C703	Q7_h2	GND	1.417E-16
C704	avI12/avC13_h6	GND	2.141E-16
C705	Q7_h6	GND	1.518E-16
C706	avI12/avC11_h6	GND	2.834E-16
C707	RST_h94	GND	5.127E-16
C708	Q7_h10	GND	1.776E-16
C709	avI2/avC6_h2	GND	1.706E-16
C710	Q0_h24	GND	1.214E-16
C711	Q5_h23	GND	1.684E-16
C712	avI2/avC6_h4	GND	1.964E-16
C713	avC15_h2	GND	1.816E-16
C714	Q0_h26	GND	1.278E-16
C715	Q5_h25	GND	2.314E-16
C716	avI2/avC6_h7	GND	1.428E-16
C717	avC15_h5	GND	1.690E-16
C718	Q0_h31	GND	1.471E-16
C719	Q5_h30	GND	7.597E-17
C720	avI3/avC6_h2	GND	1.622E-16
C721	Q6_h24	GND	1.304E-16
C722	Q7_h15	GND	1.740E-16
C723	avI3/avC6_h4	GND	1.974E-16
C724	avC16_h2	GND	1.780E-16
C725	Q6_h28	GND	1.242E-16
C726	Q7_h17	GND	2.399E-16
C727	avI3/avC6_h7	GND	1.427E-16
C728	avC16_h5	GND	1.725E-16
C729	Q6_h31	GND	1.472E-16
C730	Q7_h22	GND	1.096E-16
C731	avI4/avC6_h2	GND	1.524E-16
C732	avC16_h9	GND	1.033E-16
C733	avI4/avC6_h4	GND	1.361E-16
C734	avI4/avC6_h6	GND	1.390E-16
C735	avC14_h10	GND	1.805E-16
C736	avI4/avC7_h2	GND	2.833E-16
C737	avC14_h13	GND	4.454E-17
C738	avI4/avC10_h3	GND	1.985E-16
C739	avC15_h9	GND	1.986E-16
C740	avC16_h16	GND	3.928E-16
C741	avI4/avC10_h5	GND	1.694E-16
C742	avI4/avC7_h6	GND	2.179E-16
C743	avC15_h14	GND	8.338E-17
C744	avI4/avC7_h8	GND	7.921E-17
C745	VDD_h2	GND	6.122E-15
C746	VDD_h60	GND	4.231E-17
C747	VDD_h58	GND	5.389E-17
C748	avC14_h8	GND	4.540E-17
C749	avI5/avC10_h3	GND	9.768E-17
C750	avI5/avC12_h3	GND	1.361E-16
C751	VDD_h57	GND	3.727E-17
C752	VDD_h56	GND	3.904E-17
C753	avI5/avC9_h7	GND	1.635E-16
C754	avI5/avC11_h3	GND	1.018E-16
C755	avI5/avC13_h3	GND	1.820E-16
C756	VDD_h55	GND	3.869E-17
C757	VDD_h54	GND	4.119E-17
C758	Q0_h9	GND	5.004E-17
C759	Q0_h21	GND	4.425E-17
C760	avI6/avC10_h3	GND	1.047E-16
C761	avI6/avC12_h3	GND	1.460E-16
C762	VDD_h53	GND	4.181E-17
C763	VDD_h52	GND	4.439E-17
C764	avI6/avC9_h7	GND	1.494E-16
C765	avI6/avC11_h3	GND	9.704E-17
C766	avI6/avC13_h3	GND	1.783E-16
C767	VDD_h51	GND	4.017E-17
C768	VDD_h50	GND	3.737E-17
C769	Q1_h9	GND	6.151E-17
C770	Q1_h21	GND	4.915E-17
C771	avI7/avC10_h3	GND	1.044E-16
C772	avI7/avC12_h3	GND	1.459E-16
C773	VDD_h49	GND	4.181E-17
C774	VDD_h48	GND	4.439E-17
C775	avI7/avC9_h7	GND	1.494E-16
C776	avI7/avC11_h3	GND	9.704E-17
C777	avI7/avC13_h3	GND	1.783E-16
C778	VDD_h47	GND	4.017E-17
C779	VDD_h46	GND	3.737E-17
C780	Q2_h9	GND	6.151E-17
C781	Q2_h21	GND	4.915E-17
C782	avI8/avC10_h3	GND	1.044E-16
C783	avI8/avC12_h3	GND	1.459E-16
C784	VDD_h45	GND	4.181E-17
C785	VDD_h44	GND	4.439E-17
C786	avI8/avC9_h7	GND	1.494E-16
C787	avI8/avC11_h3	GND	9.704E-17
C788	avI8/avC13_h3	GND	1.783E-16
C789	VDD_h43	GND	4.017E-17
C790	VDD_h42	GND	3.737E-17
C791	Q3_h9	GND	6.151E-17
C792	Q3_h21	GND	4.915E-17
C793	avI9/avC10_h3	GND	1.044E-16
C794	avI9/avC12_h3	GND	1.459E-16
C795	VDD_h41	GND	4.181E-17
C796	VDD_h40	GND	4.439E-17
C797	avI9/avC9_h7	GND	1.494E-16
C798	avI9/avC11_h3	GND	9.704E-17
C799	avI9/avC13_h3	GND	1.783E-16
C800	VDD_h39	GND	4.017E-17
C801	VDD_h38	GND	3.737E-17
C802	Q4_h9	GND	6.151E-17
C803	Q4_h21	GND	4.915E-17
C804	avI10/avC10_h3	GND	1.044E-16
C805	avI10/avC12_h3	GND	1.459E-16
C806	VDD_h37	GND	4.181E-17
C807	VDD_h36	GND	4.439E-17
C808	avI10/avC9_h7	GND	1.494E-16
C809	avI10/avC11_h3	GND	9.704E-17
C810	avI10/avC13_h3	GND	1.783E-16
C811	VDD_h35	GND	4.017E-17
C812	VDD_h34	GND	3.737E-17
C813	Q5_h9	GND	6.151E-17
C814	Q5_h21	GND	4.915E-17
C815	avI11/avC10_h3	GND	1.044E-16
C816	avI11/avC12_h3	GND	1.458E-16
C817	VDD_h33	GND	4.181E-17
C818	VDD_h32	GND	4.439E-17
C819	avI11/avC9_h7	GND	1.487E-16
C820	avI11/avC11_h3	GND	9.720E-17
C821	avI11/avC13_h3	GND	1.796E-16
C822	VDD_h31	GND	4.050E-17
C823	VDD_h30	GND	3.235E-17
C824	Q6_h9	GND	5.338E-17
C825	Q6_h21	GND	4.623E-17
C826	avI12/avC10_h3	GND	9.609E-17
C827	avI12/avC12_h3	GND	1.387E-16
C828	VDD_h29	GND	4.150E-17
C829	VDD_h28	GND	4.624E-17
C830	avI12/avC9_h7	GND	1.562E-16
C831	avI12/avC11_h3	GND	9.462E-17
C832	avI12/avC13_h3	GND	1.770E-16
C833	VDD_h27	GND	3.237E-17
C834	VDD_h26	GND	2.762E-17
C835	Q7_h9	GND	7.207E-17
C836	VDD_h25	GND	6.979E-17
C837	avC15_h3	GND	7.395E-17
C838	Q5_h28	GND	7.997E-17
C839	VDD_h24	GND	6.626E-17
C840	avC16_h3	GND	7.767E-17
C841	Q7_h20	GND	8.151E-17
C842	VDD_h23	GND	4.716E-17
C843	avC14_h9	GND	1.193E-16
C844	avI4/avC10_h4	GND	1.038E-18
C845	VDD_h22	GND	6.165E-17
C846	avI4/avC10_h6	GND	7.398E-19
C847	avI4/avC7_h5	GND	1.072E-16
C848	VDD_h1	GND	3.265E-17
C849	avC13_h3	GND	3.521E-18
C850	avI5/avC12_h5	GND	3.453E-17
C851	avI5/avC12_h6	GND	4.345E-17
C852	avI5/avC9_h3	GND	4.661E-17
C853	avI5/avC9_h9	GND	5.906E-17
C854	avI5/avC13_h5	GND	2.983E-17
C855	avI5/avC13_h8	GND	4.570E-17
C856	Q0_h3	GND	2.472E-18
C857	Q0_h11	GND	6.047E-17
C858	Q0_h13	GND	6.000E-18
C859	avI6/avC12_h5	GND	3.915E-17
C860	avI6/avC12_h8	GND	4.458E-17
C861	avI6/avC9_h3	GND	4.856E-17
C862	avI6/avC9_h9	GND	5.934E-17
C863	avI6/avC13_h5	GND	2.793E-17
C864	avI6/avC13_h8	GND	4.461E-17
C865	Q1_h3	GND	3.118E-18
C866	Q1_h11	GND	6.210E-17
C867	Q1_h14	GND	6.278E-18
C868	avI7/avC12_h5	GND	3.915E-17
C869	avI7/avC12_h8	GND	4.458E-17
C870	avI7/avC9_h3	GND	4.856E-17
C871	avI7/avC9_h9	GND	5.934E-17
C872	avI7/avC13_h5	GND	2.793E-17
C873	avI7/avC13_h8	GND	4.461E-17
C874	Q2_h3	GND	3.118E-18
C875	Q2_h11	GND	6.210E-17
C876	Q2_h14	GND	6.278E-18
C877	avI8/avC12_h5	GND	3.915E-17
C878	avI8/avC12_h8	GND	4.458E-17
C879	avI8/avC9_h3	GND	4.856E-17
C880	avI8/avC9_h9	GND	5.934E-17
C881	avI8/avC13_h5	GND	2.793E-17
C882	avI8/avC13_h8	GND	4.461E-17
C883	Q3_h3	GND	3.118E-18
C884	Q3_h11	GND	6.210E-17
C885	Q3_h14	GND	6.278E-18
C886	avI9/avC12_h5	GND	3.915E-17
C887	avI9/avC12_h8	GND	4.458E-17
C888	avI9/avC9_h3	GND	4.856E-17
C889	avI9/avC9_h9	GND	5.934E-17
C890	avI9/avC13_h5	GND	2.793E-17
C891	avI9/avC13_h8	GND	4.461E-17
C892	Q4_h3	GND	3.118E-18
C893	Q4_h11	GND	6.210E-17
C894	Q4_h14	GND	6.278E-18
C895	avI10/avC12_h5	GND	3.915E-17
C896	avI10/avC12_h8	GND	4.458E-17
C897	avI10/avC9_h3	GND	4.856E-17
C898	avI10/avC9_h9	GND	5.934E-17
C899	avI10/avC13_h5	GND	2.793E-17
C900	avI10/avC13_h8	GND	4.461E-17
C901	Q5_h3	GND	3.118E-18
C902	Q5_h11	GND	6.210E-17
C903	Q5_h14	GND	6.278E-18
C904	avI11/avC12_h5	GND	3.915E-17
C905	avI11/avC12_h8	GND	4.460E-17
C906	avI11/avC9_h3	GND	5.126E-17
C907	avI11/avC9_h9	GND	6.162E-17
C908	avI11/avC13_h5	GND	2.685E-17
C909	avI11/avC13_h8	GND	4.570E-17
C910	Q6_h3	GND	3.390E-18
C911	Q6_h11	GND	6.218E-17
C912	Q6_h13	GND	6.538E-18
C913	avI12/avC12_h5	GND	3.915E-17
C914	avI12/avC12_h8	GND	4.458E-17
C915	avI12/avC9_h3	GND	4.334E-17
C916	avI12/avC9_h9	GND	5.279E-17
C917	avI12/avC13_h5	GND	2.584E-17
C918	avI12/avC13_h8	GND	4.313E-17
C919	Q7_h11	GND	6.568E-17
C920	Q5_h22	GND	8.732E-17
C921	avI2/avC6_h6	GND	4.889E-17
C922	Q7_h14	GND	6.887E-17
C923	avI3/avC6_h6	GND	4.923E-17
C924	avI4/avC6_h3	GND	4.190E-17
C925	avC14_h11	GND	7.819E-17
C926	avI4/avC7_h7	GND	3.459E-17
C927	Q5_h29	GND	8.839E-17
C928	Q7_h21	GND	9.040E-17
C929	avC13_h4	GND	1.913E-16
C930	avC14_h2	GND	1.408E-16
C931	Q0_h4	GND	5.016E-17
C932	Q0_h14	GND	1.193E-16
C933	Q1_h4	GND	5.019E-17
C934	Q1_h15	GND	1.164E-16
C935	Q2_h4	GND	5.019E-17
C936	Q2_h15	GND	1.164E-16
C937	Q3_h4	GND	5.021E-17
C938	Q3_h15	GND	1.164E-16
C939	Q4_h4	GND	5.019E-17
C940	Q4_h15	GND	1.164E-16
C941	Q5_h4	GND	5.019E-17
C942	Q5_h15	GND	1.164E-16
C943	Q6_h4	GND	5.150E-17
C944	Q6_h14	GND	1.201E-16
C945	Q7_h4	GND	4.674E-17
.ENDS MS_LFSR_8bit_RCX
simulator lang=spectre
subckt MS_LFSR_8bit CLK RST Q0 Q1 Q2 Q3 Q4 Q5 Q6 Q7 VDD GND
    XR (VDD GND CLK Q0 Q1 Q2 Q3 Q4 Q5 Q6 Q7 RST) MS_LFSR_8bit_RCX
ends MS_LFSR_8bit
