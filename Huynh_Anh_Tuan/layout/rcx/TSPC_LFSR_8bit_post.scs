// TSPC_LFSR_8bit sau layout: Assura RCX (R + C), sinh boi scripts/layout/rcx2scs.py
simulator lang=spice
.SUBCKT TSPC_LFSR_8bit_RCX VDD GND CLK Q0 Q1 Q2 Q3 Q4 Q5 Q6 Q7 RST
MavI11/avD1_1	GND_h84	RST_h64	avI11/avC9_h4	GND_h58 gpdk090_nmos1v	L=0.1U	W=0.12U
+ AD=0.0408P	AS=0.0696P	PD=0.68U	PS=1.16U
MavI11/avD1_2	avI11/avC8	Q6_h15	GND_h84	GND_h58 gpdk090_nmos1v	L=0.1U	W=0.12U
+ AD=0.0696P	AS=0.0408P	PD=1.16U	PS=0.68U
MavI11/avD1_3	avI11/avC12	avI11/avC8_h6	avI11/avC10	GND_h58 gpdk090_nmos1v
+ L=0.1U	W=0.36U
+ AD=0.0792P	AS=0.1224P	PD=0.8U	PS=1.4U
MavI11/avD1_4	GND_h83	CLK_h99	avI11/avC12	GND_h58 gpdk090_nmos1v	L=0.1U	W=0.36U
+ AD=0.0792P	AS=0.0792P	PD=0.8U	PS=0.8U
MavI11/avD1_5	avI11/avC13	avI11/avC9_h8	GND_h83	GND_h58 gpdk090_nmos1v	L=0.1U
+ W=0.36U
+ AD=0.0792P	AS=0.0792P	PD=0.8U	PS=0.8U
MavI11/avD1_6	avI11/avC14	avI11/avC10_h8	avI11/avC13	GND_h58 gpdk090_nmos1v
+ L=0.1U	W=0.36U
+ AD=0.0792P	AS=0.0792P	PD=0.8U	PS=0.8U
MavI11/avD1_7	avI11/avC11_h3	CLK_h104	avI11/avC14	GND_h58 gpdk090_nmos1v
+ L=0.1U	W=0.36U
+ AD=0.0732P	AS=0.0792P	PD=0.8U	PS=0.8U
MavI11/avD1_8	GND_h82	GND_h56	avI11/avC11_h3	GND_h58 gpdk090_nmos1v	L=0.1U	W=0.24U
+ AD=0.0528P	AS=0.0732P	PD=0.68U	PS=0.8U
MavI11/avD1_9	Q7_h3	avI11/avC11_h8	GND_h82	GND_h58 gpdk090_nmos1v	L=0.1U	W=0.24U
+ AD=0.0816P	AS=0.0528P	PD=1.16U	PS=0.68U
MavI10/avD1_1	GND_h87	RST_h56	avI10/avC9_h4	GND_h58 gpdk090_nmos1v	L=0.1U	W=0.12U
+ AD=0.0408P	AS=0.0696P	PD=0.68U	PS=1.16U
MavI10/avD1_2	avI10/avC8	Q5_h15	GND_h87	GND_h58 gpdk090_nmos1v	L=0.1U	W=0.12U
+ AD=0.0696P	AS=0.0408P	PD=1.16U	PS=0.68U
MavI10/avD1_3	avI10/avC12	avI10/avC8_h6	avI10/avC10	GND_h58 gpdk090_nmos1v
+ L=0.1U	W=0.36U
+ AD=0.0792P	AS=0.1224P	PD=0.8U	PS=1.4U
MavI10/avD1_4	GND_h86	CLK_h86	avI10/avC12	GND_h58 gpdk090_nmos1v	L=0.1U	W=0.36U
+ AD=0.0792P	AS=0.0792P	PD=0.8U	PS=0.8U
MavI10/avD1_5	avI10/avC13	avI10/avC9_h8	GND_h86	GND_h58 gpdk090_nmos1v	L=0.1U
+ W=0.36U
+ AD=0.0792P	AS=0.0792P	PD=0.8U	PS=0.8U
MavI10/avD1_6	avI10/avC14	avI10/avC10_h8	avI10/avC13	GND_h58 gpdk090_nmos1v
+ L=0.1U	W=0.36U
+ AD=0.0792P	AS=0.0792P	PD=0.8U	PS=0.8U
MavI10/avD1_7	avI10/avC11_h3	CLK_h90	avI10/avC14	GND_h58 gpdk090_nmos1v	L=0.1U
+ W=0.36U
+ AD=0.0732P	AS=0.0792P	PD=0.8U	PS=0.8U
MavI10/avD1_8	GND_h85	GND_h49	avI10/avC11_h3	GND_h58 gpdk090_nmos1v	L=0.1U	W=0.24U
+ AD=0.0528P	AS=0.0732P	PD=0.68U	PS=0.8U
MavI10/avD1_9	Q6_h3	avI10/avC11_h8	GND_h85	GND_h58 gpdk090_nmos1v	L=0.1U	W=0.24U
+ AD=0.0816P	AS=0.0528P	PD=1.16U	PS=0.68U
MavI9/avD1_1	GND_h90	RST_h48	avI9/avC9_h4	GND_h58 gpdk090_nmos1v	L=0.1U	W=0.12U
+ AD=0.0408P	AS=0.0696P	PD=0.68U	PS=1.16U
MavI9/avD1_2	avI9/avC8	Q4_h15	GND_h90	GND_h58 gpdk090_nmos1v	L=0.1U	W=0.12U
+ AD=0.0696P	AS=0.0408P	PD=1.16U	PS=0.68U
MavI9/avD1_3	avI9/avC12	avI9/avC8_h6	avI9/avC10	GND_h58 gpdk090_nmos1v
+ L=0.1U	W=0.36U
+ AD=0.0792P	AS=0.1224P	PD=0.8U	PS=1.4U
MavI9/avD1_4	GND_h89	CLK_h73	avI9/avC12	GND_h58 gpdk090_nmos1v	L=0.1U	W=0.36U
+ AD=0.0792P	AS=0.0792P	PD=0.8U	PS=0.8U
MavI9/avD1_5	avI9/avC13	avI9/avC9_h8	GND_h89	GND_h58 gpdk090_nmos1v	L=0.1U
+ W=0.36U
+ AD=0.0792P	AS=0.0792P	PD=0.8U	PS=0.8U
MavI9/avD1_6	avI9/avC14	avI9/avC10_h8	avI9/avC13	GND_h58 gpdk090_nmos1v
+ L=0.1U	W=0.36U
+ AD=0.0792P	AS=0.0792P	PD=0.8U	PS=0.8U
MavI9/avD1_7	avI9/avC11_h3	CLK_h77	avI9/avC14	GND_h58 gpdk090_nmos1v	L=0.1U
+ W=0.36U
+ AD=0.0732P	AS=0.0792P	PD=0.8U	PS=0.8U
MavI9/avD1_8	GND_h88	GND_h42	avI9/avC11_h3	GND_h58 gpdk090_nmos1v	L=0.1U	W=0.24U
+ AD=0.0528P	AS=0.0732P	PD=0.68U	PS=0.8U
MavI9/avD1_9	Q5_h3	avI9/avC11_h8	GND_h88	GND_h58 gpdk090_nmos1v	L=0.1U	W=0.24U
+ AD=0.0816P	AS=0.0528P	PD=1.16U	PS=0.68U
MavI8/avD1_1	GND_h93	RST_h40	avI8/avC9_h4	GND_h58 gpdk090_nmos1v	L=0.1U	W=0.12U
+ AD=0.0408P	AS=0.0696P	PD=0.68U	PS=1.16U
MavI8/avD1_2	avI8/avC8	Q3_h15	GND_h93	GND_h58 gpdk090_nmos1v	L=0.1U	W=0.12U
+ AD=0.0696P	AS=0.0408P	PD=1.16U	PS=0.68U
MavI8/avD1_3	avI8/avC12	avI8/avC8_h6	avI8/avC10	GND_h58 gpdk090_nmos1v
+ L=0.1U	W=0.36U
+ AD=0.0792P	AS=0.1224P	PD=0.8U	PS=1.4U
MavI8/avD1_4	GND_h92	CLK_h60	avI8/avC12	GND_h58 gpdk090_nmos1v	L=0.1U	W=0.36U
+ AD=0.0792P	AS=0.0792P	PD=0.8U	PS=0.8U
MavI8/avD1_5	avI8/avC13	avI8/avC9_h8	GND_h92	GND_h58 gpdk090_nmos1v	L=0.1U
+ W=0.36U
+ AD=0.0792P	AS=0.0792P	PD=0.8U	PS=0.8U
MavI8/avD1_6	avI8/avC14	avI8/avC10_h8	avI8/avC13	GND_h58 gpdk090_nmos1v
+ L=0.1U	W=0.36U
+ AD=0.0792P	AS=0.0792P	PD=0.8U	PS=0.8U
MavI8/avD1_7	avI8/avC11_h3	CLK_h64	avI8/avC14	GND_h58 gpdk090_nmos1v	L=0.1U
+ W=0.36U
+ AD=0.0732P	AS=0.0792P	PD=0.8U	PS=0.8U
MavI8/avD1_8	GND_h91	GND_h35	avI8/avC11_h3	GND_h58 gpdk090_nmos1v	L=0.1U	W=0.24U
+ AD=0.0528P	AS=0.0732P	PD=0.68U	PS=0.8U
MavI8/avD1_9	Q4_h3	avI8/avC11_h8	GND_h91	GND_h58 gpdk090_nmos1v	L=0.1U	W=0.24U
+ AD=0.0816P	AS=0.0528P	PD=1.16U	PS=0.68U
MavI7/avD1_1	GND_h96	RST_h32	avI7/avC9_h4	GND_h58 gpdk090_nmos1v	L=0.1U	W=0.12U
+ AD=0.0408P	AS=0.0696P	PD=0.68U	PS=1.16U
MavI7/avD1_2	avI7/avC8	Q2_h15	GND_h96	GND_h58 gpdk090_nmos1v	L=0.1U	W=0.12U
+ AD=0.0696P	AS=0.0408P	PD=1.16U	PS=0.68U
MavI7/avD1_3	avI7/avC12	avI7/avC8_h6	avI7/avC10	GND_h58 gpdk090_nmos1v
+ L=0.1U	W=0.36U
+ AD=0.0792P	AS=0.1224P	PD=0.8U	PS=1.4U
MavI7/avD1_4	GND_h95	CLK_h47	avI7/avC12	GND_h58 gpdk090_nmos1v	L=0.1U	W=0.36U
+ AD=0.0792P	AS=0.0792P	PD=0.8U	PS=0.8U
MavI7/avD1_5	avI7/avC13	avI7/avC9_h8	GND_h95	GND_h58 gpdk090_nmos1v	L=0.1U
+ W=0.36U
+ AD=0.0792P	AS=0.0792P	PD=0.8U	PS=0.8U
MavI7/avD1_6	avI7/avC14	avI7/avC10_h8	avI7/avC13	GND_h58 gpdk090_nmos1v
+ L=0.1U	W=0.36U
+ AD=0.0792P	AS=0.0792P	PD=0.8U	PS=0.8U
MavI7/avD1_7	avI7/avC11_h3	CLK_h51	avI7/avC14	GND_h58 gpdk090_nmos1v	L=0.1U
+ W=0.36U
+ AD=0.0732P	AS=0.0792P	PD=0.8U	PS=0.8U
MavI7/avD1_8	GND_h94	GND_h28	avI7/avC11_h3	GND_h58 gpdk090_nmos1v	L=0.1U	W=0.24U
+ AD=0.0528P	AS=0.0732P	PD=0.68U	PS=0.8U
MavI7/avD1_9	Q3_h3	avI7/avC11_h8	GND_h94	GND_h58 gpdk090_nmos1v	L=0.1U	W=0.24U
+ AD=0.0816P	AS=0.0528P	PD=1.16U	PS=0.68U
MavI6/avD1_1	GND_h99	RST_h24	avI6/avC9_h4	GND_h58 gpdk090_nmos1v	L=0.1U	W=0.12U
+ AD=0.0408P	AS=0.0696P	PD=0.68U	PS=1.16U
MavI6/avD1_2	avI6/avC8	Q1_h15	GND_h99	GND_h58 gpdk090_nmos1v	L=0.1U	W=0.12U
+ AD=0.0696P	AS=0.0408P	PD=1.16U	PS=0.68U
MavI6/avD1_3	avI6/avC12	avI6/avC8_h6	avI6/avC10	GND_h58 gpdk090_nmos1v
+ L=0.1U	W=0.36U
+ AD=0.0792P	AS=0.1224P	PD=0.8U	PS=1.4U
MavI6/avD1_4	GND_h98	CLK_h34	avI6/avC12	GND_h58 gpdk090_nmos1v	L=0.1U	W=0.36U
+ AD=0.0792P	AS=0.0792P	PD=0.8U	PS=0.8U
MavI6/avD1_5	avI6/avC13	avI6/avC9_h8	GND_h98	GND_h58 gpdk090_nmos1v	L=0.1U
+ W=0.36U
+ AD=0.0792P	AS=0.0792P	PD=0.8U	PS=0.8U
MavI6/avD1_6	avI6/avC14	avI6/avC10_h8	avI6/avC13	GND_h58 gpdk090_nmos1v
+ L=0.1U	W=0.36U
+ AD=0.0792P	AS=0.0792P	PD=0.8U	PS=0.8U
MavI6/avD1_7	avI6/avC11_h3	CLK_h38	avI6/avC14	GND_h58 gpdk090_nmos1v	L=0.1U
+ W=0.36U
+ AD=0.0732P	AS=0.0792P	PD=0.8U	PS=0.8U
MavI6/avD1_8	GND_h97	GND_h21	avI6/avC11_h3	GND_h58 gpdk090_nmos1v	L=0.1U	W=0.24U
+ AD=0.0528P	AS=0.0732P	PD=0.68U	PS=0.8U
MavI6/avD1_9	Q2_h3	avI6/avC11_h8	GND_h97	GND_h58 gpdk090_nmos1v	L=0.1U	W=0.24U
+ AD=0.0816P	AS=0.0528P	PD=1.16U	PS=0.68U
MavI5/avD1_1	GND_h102	RST_h16	avI5/avC9_h4	GND_h58 gpdk090_nmos1v	L=0.1U
+ W=0.12U
+ AD=0.0408P	AS=0.0696P	PD=0.68U	PS=1.16U
MavI5/avD1_2	avI5/avC8	Q0_h15	GND_h102	GND_h58 gpdk090_nmos1v	L=0.1U
+ W=0.12U
+ AD=0.0696P	AS=0.0408P	PD=1.16U	PS=0.68U
MavI5/avD1_3	avI5/avC12	avI5/avC8_h6	avI5/avC10	GND_h58 gpdk090_nmos1v
+ L=0.1U	W=0.36U
+ AD=0.0792P	AS=0.1224P	PD=0.8U	PS=1.4U
MavI5/avD1_4	GND_h101	CLK_h21	avI5/avC12	GND_h58 gpdk090_nmos1v	L=0.1U
+ W=0.36U
+ AD=0.0792P	AS=0.0792P	PD=0.8U	PS=0.8U
MavI5/avD1_5	avI5/avC13	avI5/avC9_h8	GND_h101	GND_h58 gpdk090_nmos1v
+ L=0.1U	W=0.36U
+ AD=0.0792P	AS=0.0792P	PD=0.8U	PS=0.8U
MavI5/avD1_6	avI5/avC14	avI5/avC10_h8	avI5/avC13	GND_h58 gpdk090_nmos1v
+ L=0.1U	W=0.36U
+ AD=0.0792P	AS=0.0792P	PD=0.8U	PS=0.8U
MavI5/avD1_7	avI5/avC11_h3	CLK_h25	avI5/avC14	GND_h58 gpdk090_nmos1v	L=0.1U
+ W=0.36U
+ AD=0.0732P	AS=0.0792P	PD=0.8U	PS=0.8U
MavI5/avD1_8	GND_h100	GND_h14	avI5/avC11_h3	GND_h58 gpdk090_nmos1v	L=0.1U
+ W=0.24U
+ AD=0.0528P	AS=0.0732P	PD=0.68U	PS=0.8U
MavI5/avD1_9	Q1_h3	avI5/avC11_h8	GND_h100	GND_h58 gpdk090_nmos1v	L=0.1U
+ W=0.24U
+ AD=0.0816P	AS=0.0528P	PD=1.16U	PS=0.68U
MavI4/avD1_1	GND_h105	GND_h7	avI4/avC9_h4	GND_h58 gpdk090_nmos1v	L=0.1U
+ W=0.12U
+ AD=0.0408P	AS=0.0696P	PD=0.68U	PS=1.16U
MavI4/avD1_2	avI4/avC8	avC13_h7	GND_h105	GND_h58 gpdk090_nmos1v
+ L=0.1U	W=0.12U
+ AD=0.0696P	AS=0.0408P	PD=1.16U	PS=0.68U
MavI4/avD1_3	avI4/avC12	avI4/avC8_h6	avI4/avC10	GND_h58 gpdk090_nmos1v
+ L=0.1U	W=0.36U
+ AD=0.0792P	AS=0.1224P	PD=0.8U	PS=1.4U
MavI4/avD1_4	GND_h106	CLK_h8	avI4/avC12	GND_h58 gpdk090_nmos1v	L=0.1U
+ W=0.36U
+ AD=0.0792P	AS=0.0792P	PD=0.8U	PS=0.8U
MavI4/avD1_5	avI4/avC13	avI4/avC9_h8	GND_h106	GND_h58 gpdk090_nmos1v
+ L=0.1U	W=0.36U
+ AD=0.0792P	AS=0.0792P	PD=0.8U	PS=0.8U
MavI4/avD1_6	avI4/avC14	avI4/avC10_h8	avI4/avC13	GND_h58 gpdk090_nmos1v
+ L=0.1U	W=0.36U
+ AD=0.0792P	AS=0.0792P	PD=0.8U	PS=0.8U
MavI4/avD1_7	avI4/avC11_h3	CLK_h12	avI4/avC14	GND_h58 gpdk090_nmos1v	L=0.1U
+ W=0.36U
+ AD=0.0732P	AS=0.0792P	PD=0.8U	PS=0.8U
MavI4/avD1_8	GND_h103	RST_h8	avI4/avC11_h3	GND_h58 gpdk090_nmos1v	L=0.1U
+ W=0.24U
+ AD=0.0528P	AS=0.0732P	PD=0.68U	PS=0.8U
MavI4/avD1_9	Q0_h3	avI4/avC11_h8	GND_h103	GND_h58 gpdk090_nmos1v	L=0.1U
+ W=0.24U
+ AD=0.0816P	AS=0.0528P	PD=1.16U	PS=0.68U
MavI3/avD1_1	avI3/avC6_h3	avC15_h12	GND_h79	GND_h58 gpdk090_nmos1v	L=0.1U
+ W=0.12U
+ AD=0.0696P	AS=0.0696P	PD=1.16U	PS=1.16U
MavI3/avD1_2	avI3/avC8	avI3/avC6_h8	GND_h78	GND_h58 gpdk090_nmos1v	L=0.1U
+ W=0.24U
+ AD=0.0528P	AS=0.0816P	PD=0.68U	PS=1.16U
MavI3/avD1_3	avC13_h11	avI3/avC7_h4	avI3/avC8	GND_h58 gpdk090_nmos1v
+ L=0.1U	W=0.24U
+ AD=0.0528P	AS=0.0528P	PD=0.68U	PS=0.68U
MavI3/avD1_4	avI3/avC9	avC14_h11	avC13_h11	GND_h58 gpdk090_nmos1v
+ L=0.1U	W=0.24U
+ AD=0.0528P	AS=0.0528P	PD=0.68U	PS=0.68U
MavI3/avD1_5	GND_h77	avC15_h18	avI3/avC9	GND_h58 gpdk090_nmos1v	L=0.1U
+ W=0.24U
+ AD=0.0816P	AS=0.0528P	PD=1.16U	PS=0.68U
MavI3/avD1_6	avI3/avC7_h7	avC14_h18	GND_h57	GND_h58 gpdk090_nmos1v	L=0.1U
+ W=0.12U
+ AD=0.0696P	AS=0.0696P	PD=1.16U	PS=1.16U
MavI2/avD1_1	avC15	avI2/avC6_h5	Q7_h9	GND_h58 gpdk090_nmos1v	L=0.1U	W=0.12U
+ AD=0.0468P	AS=0.1992P	PD=0.68U	PS=2.24U
MavI2/avD1_2	avI2/avC6_h6	Q7_h14	avC15	GND_h58 gpdk090_nmos1v	L=0.1U	W=0.24U
+ AD=0.0468P	AS=0.0468P	PD=0.68U	PS=0.68U
MavI2/avD1_3	GND_h80	Q6_h28	avI2/avC6_h6	GND_h58 gpdk090_nmos1v	L=0.1U	W=0.12U
+ AD=0.0696P	AS=0.0468P	PD=1.16U	PS=0.68U
MavI1/avD1_1	avC14	avI1/avC6_h5	Q5_h17	GND_h58 gpdk090_nmos1v	L=0.1U	W=0.12U
+ AD=0.0468P	AS=0.1992P	PD=0.68U	PS=2.24U
MavI1/avD1_2	avI1/avC6_h6	Q5_h22	avC14	GND_h58 gpdk090_nmos1v	L=0.1U	W=0.24U
+ AD=0.0468P	AS=0.0468P	PD=0.68U	PS=0.68U
MavI1/avD1_3	GND_h81	Q0_h28	avI1/avC6_h6	GND_h58 gpdk090_nmos1v	L=0.1U	W=0.12U
+ AD=0.0696P	AS=0.0468P	PD=1.16U	PS=0.68U
MavI11/avD7_1	VDD_h27	RST_h62	avI11/avC9	VDD_h2 gpdk090_pmos1v	L=0.1U	W=0.24U
+ AD=0.0936P	AS=0.0816P	PD=0.92U	PS=1.16U
MavI11/avD7_2	avI11/avC15	Q6_h13	VDD_h27	VDD_h2 gpdk090_pmos1v	L=0.1U	W=0.48U
+ AD=0.1056P	AS=0.0936P	PD=0.92U	PS=0.92U
MavI11/avD7_3	avI11/avC8_h5	CLK_h94	avI11/avC15	VDD_h2 gpdk090_pmos1v	L=0.1U
+ W=0.48U
+ AD=0.1632P	AS=0.1056P	PD=1.64U	PS=0.92U
MavI11/avD7_4	VDD_h26	CLK_h98	avI11/avC10_h3	VDD_h2 gpdk090_pmos1v	L=0.1U	W=0.48U
+ AD=0.0936P	AS=0.1632P	PD=0.92U	PS=1.64U
MavI11/avD7_5	avI11/avC11	avI11/avC9_h7	VDD_h26	VDD_h2 gpdk090_pmos1v	L=0.1U
+ W=0.24U
+ AD=0.0936P	AS=0.0936P	PD=0.92U	PS=0.92U
MavI11/avD7_6	avI11/avC16	avI11/avC10_h7	avI11/avC11	VDD_h2 gpdk090_pmos1v
+ L=0.1U	W=0.48U
+ AD=0.2352P	AS=0.0936P	PD=1.46U	PS=0.92U
MavI11/avD7_7	VDD_h25	GND_h54	avI11/avC16	VDD_h2 gpdk090_pmos1v	L=0.1U	W=0.48U
+ AD=0.1056P	AS=0.2352P	PD=0.92U	PS=1.46U
MavI11/avD7_8	Q7_h1	avI11/avC11_h7	VDD_h25	VDD_h2 gpdk090_pmos1v	L=0.1U	W=0.48U
+ AD=0.1632P	AS=0.1056P	PD=1.64U	PS=0.92U
MavI10/avD7_1	VDD_h30	RST_h54	avI10/avC9	VDD_h2 gpdk090_pmos1v	L=0.1U	W=0.24U
+ AD=0.0936P	AS=0.0816P	PD=0.92U	PS=1.16U
MavI10/avD7_2	avI10/avC15	Q5_h13	VDD_h30	VDD_h2 gpdk090_pmos1v	L=0.1U	W=0.48U
+ AD=0.1056P	AS=0.0936P	PD=0.92U	PS=0.92U
MavI10/avD7_3	avI10/avC8_h5	CLK_h81	avI10/avC15	VDD_h2 gpdk090_pmos1v	L=0.1U
+ W=0.48U
+ AD=0.1632P	AS=0.1056P	PD=1.64U	PS=0.92U
MavI10/avD7_4	VDD_h29	CLK_h85	avI10/avC10_h3	VDD_h2 gpdk090_pmos1v	L=0.1U	W=0.48U
+ AD=0.0936P	AS=0.1632P	PD=0.92U	PS=1.64U
MavI10/avD7_5	avI10/avC11	avI10/avC9_h7	VDD_h29	VDD_h2 gpdk090_pmos1v	L=0.1U
+ W=0.24U
+ AD=0.0936P	AS=0.0936P	PD=0.92U	PS=0.92U
MavI10/avD7_6	avI10/avC16	avI10/avC10_h7	avI10/avC11	VDD_h2 gpdk090_pmos1v
+ L=0.1U	W=0.48U
+ AD=0.2352P	AS=0.0936P	PD=1.46U	PS=0.92U
MavI10/avD7_7	VDD_h28	GND_h47	avI10/avC16	VDD_h2 gpdk090_pmos1v	L=0.1U	W=0.48U
+ AD=0.1056P	AS=0.2352P	PD=0.92U	PS=1.46U
MavI10/avD7_8	Q6_h1	avI10/avC11_h7	VDD_h28	VDD_h2 gpdk090_pmos1v	L=0.1U	W=0.48U
+ AD=0.1632P	AS=0.1056P	PD=1.64U	PS=0.92U
MavI9/avD7_1	VDD_h33	RST_h46	avI9/avC9	VDD_h2 gpdk090_pmos1v	L=0.1U	W=0.24U
+ AD=0.0936P	AS=0.0816P	PD=0.92U	PS=1.16U
MavI9/avD7_2	avI9/avC15	Q4_h13	VDD_h33	VDD_h2 gpdk090_pmos1v	L=0.1U	W=0.48U
+ AD=0.1056P	AS=0.0936P	PD=0.92U	PS=0.92U
MavI9/avD7_3	avI9/avC8_h5	CLK_h68	avI9/avC15	VDD_h2 gpdk090_pmos1v	L=0.1U
+ W=0.48U
+ AD=0.1632P	AS=0.1056P	PD=1.64U	PS=0.92U
MavI9/avD7_4	VDD_h32	CLK_h72	avI9/avC10_h3	VDD_h2 gpdk090_pmos1v	L=0.1U	W=0.48U
+ AD=0.0936P	AS=0.1632P	PD=0.92U	PS=1.64U
MavI9/avD7_5	avI9/avC11	avI9/avC9_h7	VDD_h32	VDD_h2 gpdk090_pmos1v	L=0.1U
+ W=0.24U
+ AD=0.0936P	AS=0.0936P	PD=0.92U	PS=0.92U
MavI9/avD7_6	avI9/avC16	avI9/avC10_h7	avI9/avC11	VDD_h2 gpdk090_pmos1v
+ L=0.1U	W=0.48U
+ AD=0.2352P	AS=0.0936P	PD=1.46U	PS=0.92U
MavI9/avD7_7	VDD_h31	GND_h40	avI9/avC16	VDD_h2 gpdk090_pmos1v	L=0.1U	W=0.48U
+ AD=0.1056P	AS=0.2352P	PD=0.92U	PS=1.46U
MavI9/avD7_8	Q5_h1	avI9/avC11_h7	VDD_h31	VDD_h2 gpdk090_pmos1v	L=0.1U	W=0.48U
+ AD=0.1632P	AS=0.1056P	PD=1.64U	PS=0.92U
MavI8/avD7_1	VDD_h36	RST_h38	avI8/avC9	VDD_h2 gpdk090_pmos1v	L=0.1U	W=0.24U
+ AD=0.0936P	AS=0.0816P	PD=0.92U	PS=1.16U
MavI8/avD7_2	avI8/avC15	Q3_h13	VDD_h36	VDD_h2 gpdk090_pmos1v	L=0.1U	W=0.48U
+ AD=0.1056P	AS=0.0936P	PD=0.92U	PS=0.92U
MavI8/avD7_3	avI8/avC8_h5	CLK_h55	avI8/avC15	VDD_h2 gpdk090_pmos1v	L=0.1U
+ W=0.48U
+ AD=0.1632P	AS=0.1056P	PD=1.64U	PS=0.92U
MavI8/avD7_4	VDD_h35	CLK_h59	avI8/avC10_h3	VDD_h2 gpdk090_pmos1v	L=0.1U	W=0.48U
+ AD=0.0936P	AS=0.1632P	PD=0.92U	PS=1.64U
MavI8/avD7_5	avI8/avC11	avI8/avC9_h7	VDD_h35	VDD_h2 gpdk090_pmos1v	L=0.1U
+ W=0.24U
+ AD=0.0936P	AS=0.0936P	PD=0.92U	PS=0.92U
MavI8/avD7_6	avI8/avC16	avI8/avC10_h7	avI8/avC11	VDD_h2 gpdk090_pmos1v
+ L=0.1U	W=0.48U
+ AD=0.2352P	AS=0.0936P	PD=1.46U	PS=0.92U
MavI8/avD7_7	VDD_h34	GND_h33	avI8/avC16	VDD_h2 gpdk090_pmos1v	L=0.1U	W=0.48U
+ AD=0.1056P	AS=0.2352P	PD=0.92U	PS=1.46U
MavI8/avD7_8	Q4_h1	avI8/avC11_h7	VDD_h34	VDD_h2 gpdk090_pmos1v	L=0.1U	W=0.48U
+ AD=0.1632P	AS=0.1056P	PD=1.64U	PS=0.92U
MavI7/avD7_1	VDD_h39	RST_h30	avI7/avC9	VDD_h2 gpdk090_pmos1v	L=0.1U	W=0.24U
+ AD=0.0936P	AS=0.0816P	PD=0.92U	PS=1.16U
MavI7/avD7_2	avI7/avC15	Q2_h13	VDD_h39	VDD_h2 gpdk090_pmos1v	L=0.1U	W=0.48U
+ AD=0.1056P	AS=0.0936P	PD=0.92U	PS=0.92U
MavI7/avD7_3	avI7/avC8_h5	CLK_h42	avI7/avC15	VDD_h2 gpdk090_pmos1v	L=0.1U
+ W=0.48U
+ AD=0.1632P	AS=0.1056P	PD=1.64U	PS=0.92U
MavI7/avD7_4	VDD_h38	CLK_h46	avI7/avC10_h3	VDD_h2 gpdk090_pmos1v	L=0.1U	W=0.48U
+ AD=0.0936P	AS=0.1632P	PD=0.92U	PS=1.64U
MavI7/avD7_5	avI7/avC11	avI7/avC9_h7	VDD_h38	VDD_h2 gpdk090_pmos1v	L=0.1U
+ W=0.24U
+ AD=0.0936P	AS=0.0936P	PD=0.92U	PS=0.92U
MavI7/avD7_6	avI7/avC16	avI7/avC10_h7	avI7/avC11	VDD_h2 gpdk090_pmos1v
+ L=0.1U	W=0.48U
+ AD=0.2352P	AS=0.0936P	PD=1.46U	PS=0.92U
MavI7/avD7_7	VDD_h37	GND_h26	avI7/avC16	VDD_h2 gpdk090_pmos1v	L=0.1U	W=0.48U
+ AD=0.1056P	AS=0.2352P	PD=0.92U	PS=1.46U
MavI7/avD7_8	Q3_h1	avI7/avC11_h7	VDD_h37	VDD_h2 gpdk090_pmos1v	L=0.1U	W=0.48U
+ AD=0.1632P	AS=0.1056P	PD=1.64U	PS=0.92U
MavI6/avD7_1	VDD_h42	RST_h22	avI6/avC9	VDD_h2 gpdk090_pmos1v	L=0.1U	W=0.24U
+ AD=0.0936P	AS=0.0816P	PD=0.92U	PS=1.16U
MavI6/avD7_2	avI6/avC15	Q1_h13	VDD_h42	VDD_h2 gpdk090_pmos1v	L=0.1U	W=0.48U
+ AD=0.1056P	AS=0.0936P	PD=0.92U	PS=0.92U
MavI6/avD7_3	avI6/avC8_h5	CLK_h29	avI6/avC15	VDD_h2 gpdk090_pmos1v	L=0.1U
+ W=0.48U
+ AD=0.1632P	AS=0.1056P	PD=1.64U	PS=0.92U
MavI6/avD7_4	VDD_h41	CLK_h33	avI6/avC10_h3	VDD_h2 gpdk090_pmos1v	L=0.1U	W=0.48U
+ AD=0.0936P	AS=0.1632P	PD=0.92U	PS=1.64U
MavI6/avD7_5	avI6/avC11	avI6/avC9_h7	VDD_h41	VDD_h2 gpdk090_pmos1v	L=0.1U
+ W=0.24U
+ AD=0.0936P	AS=0.0936P	PD=0.92U	PS=0.92U
MavI6/avD7_6	avI6/avC16	avI6/avC10_h7	avI6/avC11	VDD_h2 gpdk090_pmos1v
+ L=0.1U	W=0.48U
+ AD=0.2352P	AS=0.0936P	PD=1.46U	PS=0.92U
MavI6/avD7_7	VDD_h40	GND_h19	avI6/avC16	VDD_h2 gpdk090_pmos1v	L=0.1U	W=0.48U
+ AD=0.1056P	AS=0.2352P	PD=0.92U	PS=1.46U
MavI6/avD7_8	Q2_h1	avI6/avC11_h7	VDD_h40	VDD_h2 gpdk090_pmos1v	L=0.1U	W=0.48U
+ AD=0.1632P	AS=0.1056P	PD=1.64U	PS=0.92U
MavI5/avD7_1	VDD_h45	RST_h14	avI5/avC9	VDD_h2 gpdk090_pmos1v	L=0.1U	W=0.24U
+ AD=0.0936P	AS=0.0816P	PD=0.92U	PS=1.16U
MavI5/avD7_2	avI5/avC15	Q0_h13	VDD_h45	VDD_h2 gpdk090_pmos1v	L=0.1U	W=0.48U
+ AD=0.1056P	AS=0.0936P	PD=0.92U	PS=0.92U
MavI5/avD7_3	avI5/avC8_h5	CLK_h16	avI5/avC15	VDD_h2 gpdk090_pmos1v	L=0.1U
+ W=0.48U
+ AD=0.1632P	AS=0.1056P	PD=1.64U	PS=0.92U
MavI5/avD7_4	VDD_h44	CLK_h20	avI5/avC10_h3	VDD_h2 gpdk090_pmos1v	L=0.1U	W=0.48U
+ AD=0.0936P	AS=0.1632P	PD=0.92U	PS=1.64U
MavI5/avD7_5	avI5/avC11	avI5/avC9_h7	VDD_h44	VDD_h2 gpdk090_pmos1v	L=0.1U
+ W=0.24U
+ AD=0.0936P	AS=0.0936P	PD=0.92U	PS=0.92U
MavI5/avD7_6	avI5/avC16	avI5/avC10_h7	avI5/avC11	VDD_h2 gpdk090_pmos1v
+ L=0.1U	W=0.48U
+ AD=0.2352P	AS=0.0936P	PD=1.46U	PS=0.92U
MavI5/avD7_7	VDD_h43	GND_h12	avI5/avC16	VDD_h2 gpdk090_pmos1v	L=0.1U	W=0.48U
+ AD=0.1056P	AS=0.2352P	PD=0.92U	PS=1.46U
MavI5/avD7_8	Q1_h1	avI5/avC11_h7	VDD_h43	VDD_h2 gpdk090_pmos1v	L=0.1U	W=0.48U
+ AD=0.1632P	AS=0.1056P	PD=1.64U	PS=0.92U
MavI4/avD7_1	VDD_h49	GND_h5	avI4/avC9	VDD_h2 gpdk090_pmos1v	L=0.1U	W=0.24U
+ AD=0.0936P	AS=0.0816P	PD=0.92U	PS=1.16U
MavI4/avD7_2	avI4/avC15	avC13_h5	VDD_h49	VDD_h2 gpdk090_pmos1v	L=0.1U
+ W=0.48U
+ AD=0.1056P	AS=0.0936P	PD=0.92U	PS=0.92U
MavI4/avD7_3	avI4/avC8_h5	CLK_h3	avI4/avC15	VDD_h2 gpdk090_pmos1v	L=0.1U
+ W=0.48U
+ AD=0.1632P	AS=0.1056P	PD=1.64U	PS=0.92U
MavI4/avD7_4	VDD_h47	CLK_h7	avI4/avC10_h3	VDD_h2 gpdk090_pmos1v	L=0.1U	W=0.48U
+ AD=0.0936P	AS=0.1632P	PD=0.92U	PS=1.64U
MavI4/avD7_5	avI4/avC11	avI4/avC9_h7	VDD_h47	VDD_h2 gpdk090_pmos1v	L=0.1U
+ W=0.24U
+ AD=0.0936P	AS=0.0936P	PD=0.92U	PS=0.92U
MavI4/avD7_6	avI4/avC16	avI4/avC10_h7	avI4/avC11	VDD_h2 gpdk090_pmos1v
+ L=0.1U	W=0.48U
+ AD=0.2352P	AS=0.0936P	PD=1.46U	PS=0.92U
MavI4/avD7_7	VDD_h46	RST_h6	avI4/avC16	VDD_h2 gpdk090_pmos1v	L=0.1U	W=0.48U
+ AD=0.1056P	AS=0.2352P	PD=0.92U	PS=1.46U
MavI4/avD7_8	Q0_h1	avI4/avC11_h7	VDD_h46	VDD_h2 gpdk090_pmos1v	L=0.1U	W=0.48U
+ AD=0.1632P	AS=0.1056P	PD=1.64U	PS=0.92U
MavI3/avD7_1	VDD_h22	avC15_h11	avI3/avC6	VDD_h2 gpdk090_pmos1v	L=0.1U
+ W=0.24U
+ AD=0.0816P	AS=0.0816P	PD=1.16U	PS=1.16U
MavI3/avD7_2	avC13_h9	avI3/avC6_h7	avI3/avC10_h2	VDD_h2 gpdk090_pmos1v
+ L=0.1U	W=0.48U
+ AD=0.1056P	AS=0.1632P	PD=0.92U	PS=1.64U
MavI3/avD7_3	avI3/avC10_h4	avI3/avC7_h3	avC13_h9	VDD_h2 gpdk090_pmos1v
+ L=0.1U	W=0.48U
+ AD=0.1056P	AS=0.1056P	PD=0.92U	PS=0.92U
MavI3/avD7_4	VDD_h21	avC14_h10	avI3/avC10_h4	VDD_h2 gpdk090_pmos1v	L=0.1U
+ W=0.48U
+ AD=0.1056P	AS=0.1056P	PD=0.92U	PS=0.92U
MavI3/avD7_5	avI3/avC10_h6	avC15_h17	VDD_h21	VDD_h2 gpdk090_pmos1v	L=0.1U
+ W=0.48U
+ AD=0.1632P	AS=0.1056P	PD=1.64U	PS=0.92U
MavI3/avD7_6	VDD_h1	avC14_h16	avI3/avC7_h5	VDD_h2 gpdk090_pmos1v	L=0.1U
+ W=0.24U
+ AD=0.0816P	AS=0.0816P	PD=1.16U	PS=1.16U
MavI2/avD7_1	VDD_h23	Q6_h20	avI2/avC6	VDD_h2 gpdk090_pmos1v	L=0.1U	W=0.24U
+ AD=0.0816P	AS=0.0816P	PD=1.16U	PS=1.16U
MavI2/avD7_2	avC15_h3	Q7_h13	Q6_h22	VDD_h2 gpdk090_pmos1v	L=0.1U	W=0.48U
+ AD=0.0936P	AS=0.1632P	PD=0.92U	PS=1.64U
MavI2/avD7_3	Q7_h15	Q6_h27	avC15_h3	VDD_h2 gpdk090_pmos1v	L=0.1U	W=0.24U
+ AD=0.0816P	AS=0.0936P	PD=1.16U	PS=0.92U
MavI1/avD7_1	VDD_h24	Q0_h20	avI1/avC6	VDD_h2 gpdk090_pmos1v	L=0.1U	W=0.24U
+ AD=0.0816P	AS=0.0816P	PD=1.16U	PS=1.16U
MavI1/avD7_2	avC14_h3	Q5_h21	Q0_h24	VDD_h2 gpdk090_pmos1v	L=0.1U	W=0.48U
+ AD=0.0936P	AS=0.1632P	PD=0.92U	PS=1.64U
MavI1/avD7_3	Q5_h23	Q0_h27	avC14_h3	VDD_h2 gpdk090_pmos1v	L=0.1U	W=0.24U
+ AD=0.0816P	AS=0.0936P	PD=1.16U	PS=0.92U
Rj1	GND_h5	GND_h6	   48.5435
Rj2	GND_h6	GND_h7	   54.5435
Rj3	GND_h1	GND_h6	   10.0000
Rj4	avC13_h5	avC13_h6	   36.5435
Rj5	avC13_h6	avC13_h7	   54.5435
Rj6	avC13	avC13_h6	   10.0000
Rj7	CLK_h3	CLK_h1	   36.5435
Rj8	avI4/avC8_h6	avI4/avC8_h3	   36.5435
Rj9	CLK_h7	CLK_h4	   36.5435
Rj10	CLK_h4	CLK_h8	   36.5435
Rj11	avI4/avC9_h7	avI4/avC9_h5	   48.5435
Rj12	avI4/avC9_h5	avI4/avC9_h8	   36.5435
Rj13	avI4/avC10_h7	avI4/avC10_h5	   36.5435
Rj14	avI4/avC10_h5	avI4/avC10_h8	   36.5435
Rj15	CLK_h12	CLK_h9	   36.5435
Rj16	RST_h6	RST_h7	   36.5435
Rj17	RST_h7	RST_h8	   48.5435
Rj18	RST_h1	RST_h7	   10.0000
Rj19	avI4/avC11_h7	avI4/avC11_h5	   36.5435
Rj20	avI4/avC11_h5	avI4/avC11_h8	   48.5435
Rj21	RST_h14	RST_h15	   48.5435
Rj22	RST_h15	RST_h16	   54.5435
Rj23	RST_h9	RST_h15	   10.0000
Rj24	Q0_h13	Q0_h14	   36.5435
Rj25	Q0_h14	Q0_h15	   54.5435
Rj26	Q0_h9	Q0_h14	   10.0000
Rj27	CLK_h16	CLK_h14	   36.5435
Rj28	avI5/avC8_h6	avI5/avC8_h3	   36.5435
Rj29	CLK_h20	CLK_h17	   36.5435
Rj30	CLK_h17	CLK_h21	   36.5435
Rj31	avI5/avC9_h7	avI5/avC9_h5	   48.5435
Rj32	avI5/avC9_h5	avI5/avC9_h8	   36.5435
Rj33	avI5/avC10_h7	avI5/avC10_h5	   36.5435
Rj34	avI5/avC10_h5	avI5/avC10_h8	   36.5435
Rj35	CLK_h25	CLK_h22	   36.5435
Rj36	GND_h12	GND_h13	   36.5435
Rj37	GND_h13	GND_h14	   48.5435
Rj38	GND_h8	GND_h13	   10.0000
Rj39	avI5/avC11_h7	avI5/avC11_h5	   36.5435
Rj40	avI5/avC11_h5	avI5/avC11_h8	   48.5435
Rj41	RST_h22	RST_h23	   48.5435
Rj42	RST_h23	RST_h24	   54.5435
Rj43	RST_h17	RST_h23	   10.0000
Rj44	Q1_h13	Q1_h14	   36.5435
Rj45	Q1_h14	Q1_h15	   54.5435
Rj46	Q1_h9	Q1_h14	   10.0000
Rj47	CLK_h29	CLK_h27	   36.5435
Rj48	avI6/avC8_h6	avI6/avC8_h3	   36.5435
Rj49	CLK_h33	CLK_h30	   36.5435
Rj50	CLK_h30	CLK_h34	   36.5435
Rj51	avI6/avC9_h7	avI6/avC9_h5	   48.5435
Rj52	avI6/avC9_h5	avI6/avC9_h8	   36.5435
Rj53	avI6/avC10_h7	avI6/avC10_h5	   36.5435
Rj54	avI6/avC10_h5	avI6/avC10_h8	   36.5435
Rj55	CLK_h38	CLK_h35	   36.5435
Rj56	GND_h19	GND_h20	   36.5435
Rj57	GND_h20	GND_h21	   48.5435
Rj58	GND_h15	GND_h20	   10.0000
Rj59	avI6/avC11_h7	avI6/avC11_h5	   36.5435
Rj60	avI6/avC11_h5	avI6/avC11_h8	   48.5435
Rj61	RST_h30	RST_h31	   48.5435
Rj62	RST_h31	RST_h32	   54.5435
Rj63	RST_h25	RST_h31	   10.0000
Rj64	Q2_h13	Q2_h14	   36.5435
Rj65	Q2_h14	Q2_h15	   54.5435
Rj66	Q2_h9	Q2_h14	   10.0000
Rj67	CLK_h42	CLK_h40	   36.5435
Rj68	avI7/avC8_h6	avI7/avC8_h3	   36.5435
Rj69	CLK_h46	CLK_h43	   36.5435
Rj70	CLK_h43	CLK_h47	   36.5435
Rj71	avI7/avC9_h7	avI7/avC9_h5	   48.5435
Rj72	avI7/avC9_h5	avI7/avC9_h8	   36.5435
Rj73	avI7/avC10_h7	avI7/avC10_h5	   36.5435
Rj74	avI7/avC10_h5	avI7/avC10_h8	   36.5435
Rj75	CLK_h51	CLK_h48	   36.5435
Rj76	GND_h26	GND_h27	   36.5435
Rj77	GND_h27	GND_h28	   48.5435
Rj78	GND_h22	GND_h27	   10.0000
Rj79	avI7/avC11_h7	avI7/avC11_h5	   36.5435
Rj80	avI7/avC11_h5	avI7/avC11_h8	   48.5435
Rj81	RST_h38	RST_h39	   48.5435
Rj82	RST_h39	RST_h40	   54.5435
Rj83	RST_h33	RST_h39	   10.0000
Rj84	Q3_h13	Q3_h14	   36.5435
Rj85	Q3_h14	Q3_h15	   54.5435
Rj86	Q3_h9	Q3_h14	   10.0000
Rj87	CLK_h55	CLK_h53	   36.5435
Rj88	avI8/avC8_h6	avI8/avC8_h3	   36.5435
Rj89	CLK_h59	CLK_h56	   36.5435
Rj90	CLK_h56	CLK_h60	   36.5435
Rj91	avI8/avC9_h7	avI8/avC9_h5	   48.5435
Rj92	avI8/avC9_h5	avI8/avC9_h8	   36.5435
Rj93	avI8/avC10_h7	avI8/avC10_h5	   36.5435
Rj94	avI8/avC10_h5	avI8/avC10_h8	   36.5435
Rj95	CLK_h64	CLK_h61	   36.5435
Rj96	GND_h33	GND_h34	   36.5435
Rj97	GND_h34	GND_h35	   48.5435
Rj98	GND_h29	GND_h34	   10.0000
Rj99	avI8/avC11_h7	avI8/avC11_h5	   36.5435
Rj100	avI8/avC11_h5	avI8/avC11_h8	   48.5435
Rj101	RST_h46	RST_h47	   48.5435
Rj102	RST_h47	RST_h48	   54.5435
Rj103	RST_h41	RST_h47	   10.0000
Rj104	Q4_h13	Q4_h14	   36.5435
Rj105	Q4_h14	Q4_h15	   54.5435
Rj106	Q4_h9	Q4_h14	   10.0000
Rj107	CLK_h68	CLK_h66	   36.5435
Rj108	avI9/avC8_h6	avI9/avC8_h3	   36.5435
Rj109	CLK_h72	CLK_h69	   36.5435
Rj110	CLK_h69	CLK_h73	   36.5435
Rj111	avI9/avC9_h7	avI9/avC9_h5	   48.5435
Rj112	avI9/avC9_h5	avI9/avC9_h8	   36.5435
Rj113	avI9/avC10_h7	avI9/avC10_h5	   36.5435
Rj114	avI9/avC10_h5	avI9/avC10_h8	   36.5435
Rj115	CLK_h77	CLK_h74	   36.5435
Rj116	GND_h40	GND_h41	   36.5435
Rj117	GND_h41	GND_h42	   48.5435
Rj118	GND_h36	GND_h41	   10.0000
Rj119	avI9/avC11_h7	avI9/avC11_h5	   36.5435
Rj120	avI9/avC11_h5	avI9/avC11_h8	   48.5435
Rj121	RST_h54	RST_h55	   48.5435
Rj122	RST_h55	RST_h56	   54.5435
Rj123	RST_h49	RST_h55	   10.0000
Rj124	Q5_h13	Q5_h14	   36.5435
Rj125	Q5_h14	Q5_h15	   54.5435
Rj126	Q5_h9	Q5_h14	   10.0000
Rj127	CLK_h81	CLK_h79	   36.5435
Rj128	avI10/avC8_h6	avI10/avC8_h3	   36.5435
Rj129	CLK_h85	CLK_h82	   36.5435
Rj130	CLK_h82	CLK_h86	   36.5435
Rj131	avI10/avC9_h7	avI10/avC9_h5	   48.5435
Rj132	avI10/avC9_h5	avI10/avC9_h8	   36.5435
Rj133	avI10/avC10_h7	avI10/avC10_h5	   36.5435
Rj134	avI10/avC10_h5	avI10/avC10_h8	   36.5435
Rj135	CLK_h90	CLK_h87	   36.5435
Rj136	GND_h47	GND_h48	   36.5435
Rj137	GND_h48	GND_h49	   48.5435
Rj138	GND_h43	GND_h48	   10.0000
Rj139	avI10/avC11_h7	avI10/avC11_h5	   36.5435
Rj140	avI10/avC11_h5	avI10/avC11_h8	   48.5435
Rj141	RST_h62	RST_h63	   48.5435
Rj142	RST_h63	RST_h64	   54.5435
Rj143	RST_h57	RST_h63	   10.0000
Rj144	Q6_h13	Q6_h14	   36.5435
Rj145	Q6_h14	Q6_h15	   54.5435
Rj146	Q6_h9	Q6_h14	   10.0000
Rj147	CLK_h94	CLK_h92	   36.5435
Rj148	avI11/avC8_h6	avI11/avC8_h3	   36.5435
Rj149	CLK_h98	CLK_h95	   36.5435
Rj150	CLK_h95	CLK_h99	   36.5435
Rj151	avI11/avC9_h7	avI11/avC9_h5	   48.5435
Rj152	avI11/avC9_h5	avI11/avC9_h8	   36.5435
Rj153	avI11/avC10_h7	avI11/avC10_h5	   36.5435
Rj154	avI11/avC10_h5	avI11/avC10_h8	   36.5435
Rj155	CLK_h104	CLK_h101	   36.5435
Rj156	GND_h54	GND_h55	   36.5435
Rj157	GND_h55	GND_h56	   48.5435
Rj158	GND_h50	GND_h55	   10.0000
Rj159	avI11/avC11_h7	avI11/avC11_h5	   36.5435
Rj160	avI11/avC11_h5	avI11/avC11_h8	   48.5435
Rj161	Q0_h20	Q0_h17	   58.5435
Rj162	avI1/avC6_h5	avI1/avC6_h3	   54.5435
Rj163	Q5_h21	Q5_h19	   36.5435
Rj164	Q5_h19	Q5_h22	   48.5435
Rj165	Q0_h27	Q0_h25	   48.5435
Rj166	Q0_h25	Q0_h28	   54.5435
Rj167	Q6_h20	Q6_h17	   58.5435
Rj168	avI2/avC6_h5	avI2/avC6_h3	   54.5435
Rj169	Q7_h13	Q7_h11	   36.5435
Rj170	Q7_h11	Q7_h14	   48.5435
Rj171	Q6_h27	Q6_h25	   48.5435
Rj172	Q6_h25	Q6_h28	   54.5435
Rj173	avC15_h11	avC15_h8	   48.5435
Rj174	avC15_h8	avC15_h12	   54.5435
Rj175	avI3/avC6_h7	avI3/avC6_h5	   36.5435
Rj176	avI3/avC6_h5	avI3/avC6_h8	   48.5435
Rj177	avI3/avC7_h3	avI3/avC7	   36.5435
Rj178	avI3/avC7	avI3/avC7_h4	   48.5435
Rj179	avC14_h10	avC14_h8	   36.5435
Rj180	avC14_h8	avC14_h11	   48.5435
Rj181	avC15_h17	avC15_h15	   36.5435
Rj182	avC15_h15	avC15_h18	   48.5435
Rj183	avC14_h16	avC14_h17	   48.5435
Rj184	avC14_h17	avC14_h18	   54.5435
Rj185	avC14_h12	avC14_h17	   10.0000
Ri1	avI4/avC9_h2	avI4/avC9_h3	2.667E-02
Ri2	avI4/avC9_h3	avI4/avC9_h4	   15.6987
Ri3	avI4/avC9	avI4/avC9_h2	   15.0000
Ri5	GND_h1	GND_h3	    1.6827
Ri7	avC13	avC13_h3	    1.8907
Ri8	avI4/avC8	avI4/avC8_h2	   16.9440
Ri9	CLK_h1	CLK_h2	   11.4267
Ri10	avI4/avC10	avI4/avC10_h2	   16.6347
Ri11	avI4/avC8_h3	avI4/avC8_h4	   10.2807
Ri12	avI4/avC8_h4	avI4/avC8_h5	   15.1813
Ri13	avI4/avC10_h3	avI4/avC10_h4	   16.8907
Ri14	CLK_h4	CLK_h5	   10.0000
Ri15	CLK_h5	CLK_h6	    1.4267
Ri16	avI4/avC9_h5	avI4/avC9_h6	   11.7360
Ri17	avI4/avC11	avI4/avC11_h2	   16.5813
Ri18	avI4/avC10_h5	avI4/avC10_h6	   11.5280
Ri19	CLK_h9	CLK_h10	   11.4267
Ri20	avI4/avC11_h3	avI4/avC11_h4	   16.9440
Ri22	RST_h1	RST_h3	    1.6827
Ri23	avI4/avC11_h5	avI4/avC11_h6	   11.5813
Ri24	Q0_h2	Q0_h4	    0.7253
Ri26	Q0_h2	Q0_h6	    1.5280
Ri27	Q0_h1	Q0_h2	   15.0000
Ri28	Q0_h3	Q0_h4	   15.0000
Ri29	avI5/avC9_h2	avI5/avC9_h3	2.667E-02
Ri30	avI5/avC9_h3	avI5/avC9_h4	   15.6987
Ri31	avI5/avC9	avI5/avC9_h2	   15.0000
Ri33	RST_h9	RST_h11	    1.6827
Ri35	Q0_h9	Q0_h11	    1.8907
Ri36	avI5/avC8	avI5/avC8_h2	   16.9440
Ri37	CLK_h14	CLK_h15	   11.4267
Ri38	avI5/avC10	avI5/avC10_h2	   16.6347
Ri39	avI5/avC8_h3	avI5/avC8_h4	   10.2807
Ri40	avI5/avC8_h4	avI5/avC8_h5	   15.1813
Ri41	avI5/avC10_h3	avI5/avC10_h4	   16.8907
Ri42	CLK_h17	CLK_h18	   10.0000
Ri43	CLK_h18	CLK_h19	    1.4267
Ri44	avI5/avC9_h5	avI5/avC9_h6	   11.7360
Ri45	avI5/avC11	avI5/avC11_h2	   16.5813
Ri46	avI5/avC10_h5	avI5/avC10_h6	   11.5280
Ri47	CLK_h22	CLK_h23	   11.4267
Ri48	avI5/avC11_h3	avI5/avC11_h4	   16.9440
Ri50	GND_h8	GND_h10	    1.6827
Ri51	avI5/avC11_h5	avI5/avC11_h6	   11.5813
Ri52	Q1_h2	Q1_h4	    0.7253
Ri54	Q1_h2	Q1_h6	    1.5280
Ri55	Q1_h1	Q1_h2	   15.0000
Ri56	Q1_h3	Q1_h4	   15.0000
Ri57	avI6/avC9_h2	avI6/avC9_h3	2.667E-02
Ri58	avI6/avC9_h3	avI6/avC9_h4	   15.6987
Ri59	avI6/avC9	avI6/avC9_h2	   15.0000
Ri61	RST_h17	RST_h19	    1.6827
Ri63	Q1_h9	Q1_h11	    1.8907
Ri64	avI6/avC8	avI6/avC8_h2	   16.9440
Ri65	CLK_h27	CLK_h28	   11.4267
Ri66	avI6/avC10	avI6/avC10_h2	   16.6347
Ri67	avI6/avC8_h3	avI6/avC8_h4	   10.2807
Ri68	avI6/avC8_h4	avI6/avC8_h5	   15.1813
Ri69	avI6/avC10_h3	avI6/avC10_h4	   16.8907
Ri70	CLK_h30	CLK_h31	   10.0000
Ri71	CLK_h31	CLK_h32	    1.4267
Ri72	avI6/avC9_h5	avI6/avC9_h6	   11.7360
Ri73	avI6/avC11	avI6/avC11_h2	   16.5813
Ri74	avI6/avC10_h5	avI6/avC10_h6	   11.5280
Ri75	CLK_h35	CLK_h36	   11.4267
Ri76	avI6/avC11_h3	avI6/avC11_h4	   16.9440
Ri78	GND_h15	GND_h17	    1.6827
Ri79	avI6/avC11_h5	avI6/avC11_h6	   11.5813
Ri80	Q2_h2	Q2_h4	    0.7253
Ri82	Q2_h2	Q2_h6	    1.5280
Ri83	Q2_h1	Q2_h2	   15.0000
Ri84	Q2_h3	Q2_h4	   15.0000
Ri85	avI7/avC9_h2	avI7/avC9_h3	2.667E-02
Ri86	avI7/avC9_h3	avI7/avC9_h4	   15.6987
Ri87	avI7/avC9	avI7/avC9_h2	   15.0000
Ri89	RST_h25	RST_h27	    1.6827
Ri91	Q2_h9	Q2_h11	    1.8907
Ri92	avI7/avC8	avI7/avC8_h2	   16.9440
Ri93	CLK_h40	CLK_h41	   11.4267
Ri94	avI7/avC10	avI7/avC10_h2	   16.6347
Ri95	avI7/avC8_h3	avI7/avC8_h4	   10.2807
Ri96	avI7/avC8_h4	avI7/avC8_h5	   15.1813
Ri97	avI7/avC10_h3	avI7/avC10_h4	   16.8907
Ri98	CLK_h43	CLK_h44	   10.0000
Ri99	CLK_h44	CLK_h45	    1.4267
Ri100	avI7/avC9_h5	avI7/avC9_h6	   11.7360
Ri101	avI7/avC11	avI7/avC11_h2	   16.5813
Ri102	avI7/avC10_h5	avI7/avC10_h6	   11.5280
Ri103	CLK_h48	CLK_h49	   11.4267
Ri104	avI7/avC11_h3	avI7/avC11_h4	   16.9440
Ri106	GND_h22	GND_h24	    1.6827
Ri107	avI7/avC11_h5	avI7/avC11_h6	   11.5813
Ri108	Q3_h2	Q3_h4	    0.7253
Ri110	Q3_h2	Q3_h6	    1.5280
Ri111	Q3_h1	Q3_h2	   15.0000
Ri112	Q3_h3	Q3_h4	   15.0000
Ri113	avI8/avC9_h2	avI8/avC9_h3	2.667E-02
Ri114	avI8/avC9_h3	avI8/avC9_h4	   15.6987
Ri115	avI8/avC9	avI8/avC9_h2	   15.0000
Ri117	RST_h33	RST_h35	    1.6827
Ri119	Q3_h9	Q3_h11	    1.8907
Ri120	avI8/avC8	avI8/avC8_h2	   16.9440
Ri121	CLK_h53	CLK_h54	   11.4267
Ri122	avI8/avC10	avI8/avC10_h2	   16.6347
Ri123	avI8/avC8_h3	avI8/avC8_h4	   10.2807
Ri124	avI8/avC8_h4	avI8/avC8_h5	   15.1813
Ri125	avI8/avC10_h3	avI8/avC10_h4	   16.8907
Ri126	CLK_h56	CLK_h57	   10.0000
Ri127	CLK_h57	CLK_h58	    1.4267
Ri128	avI8/avC9_h5	avI8/avC9_h6	   11.7360
Ri129	avI8/avC11	avI8/avC11_h2	   16.5813
Ri130	avI8/avC10_h5	avI8/avC10_h6	   11.5280
Ri131	CLK_h61	CLK_h62	   11.4267
Ri132	avI8/avC11_h3	avI8/avC11_h4	   16.9440
Ri134	GND_h29	GND_h31	    1.6827
Ri135	avI8/avC11_h5	avI8/avC11_h6	   11.5813
Ri136	Q4_h2	Q4_h4	    0.7253
Ri138	Q4_h2	Q4_h6	    1.5280
Ri139	Q4_h1	Q4_h2	   15.0000
Ri140	Q4_h3	Q4_h4	   15.0000
Ri141	avI9/avC9_h2	avI9/avC9_h3	2.667E-02
Ri142	avI9/avC9_h3	avI9/avC9_h4	   15.6987
Ri143	avI9/avC9	avI9/avC9_h2	   15.0000
Ri145	RST_h41	RST_h43	    1.6827
Ri147	Q4_h9	Q4_h11	    1.8907
Ri148	avI9/avC8	avI9/avC8_h2	   16.9440
Ri149	CLK_h66	CLK_h67	   11.4267
Ri150	avI9/avC10	avI9/avC10_h2	   16.6347
Ri151	avI9/avC8_h3	avI9/avC8_h4	   10.2807
Ri152	avI9/avC8_h4	avI9/avC8_h5	   15.1813
Ri153	avI9/avC10_h3	avI9/avC10_h4	   16.8907
Ri154	CLK_h69	CLK_h70	   10.0000
Ri155	CLK_h70	CLK_h71	    1.4267
Ri156	avI9/avC9_h5	avI9/avC9_h6	   11.7360
Ri157	avI9/avC11	avI9/avC11_h2	   16.5813
Ri158	avI9/avC10_h5	avI9/avC10_h6	   11.5280
Ri159	CLK_h74	CLK_h75	   11.4267
Ri160	avI9/avC11_h3	avI9/avC11_h4	   16.9440
Ri162	GND_h36	GND_h38	    1.6827
Ri163	avI9/avC11_h5	avI9/avC11_h6	   11.5813
Ri164	Q5_h2	Q5_h4	    0.7253
Ri166	Q5_h2	Q5_h6	    1.5280
Ri167	Q5_h1	Q5_h2	   15.0000
Ri168	Q5_h3	Q5_h4	   15.0000
Ri169	avI10/avC9_h2	avI10/avC9_h3	2.667E-02
Ri170	avI10/avC9_h3	avI10/avC9_h4	   15.6987
Ri171	avI10/avC9	avI10/avC9_h2	   15.0000
Ri173	RST_h49	RST_h51	    1.6827
Ri175	Q5_h9	Q5_h11	    1.8907
Ri176	avI10/avC8	avI10/avC8_h2	   16.9440
Ri177	CLK_h79	CLK_h80	   11.4267
Ri178	avI10/avC10	avI10/avC10_h2	   16.6347
Ri179	avI10/avC8_h3	avI10/avC8_h4	   10.2807
Ri180	avI10/avC8_h4	avI10/avC8_h5	   15.1813
Ri181	avI10/avC10_h3	avI10/avC10_h4	   16.8907
Ri182	CLK_h82	CLK_h83	   10.0000
Ri183	CLK_h83	CLK_h84	    1.4267
Ri184	avI10/avC9_h5	avI10/avC9_h6	   11.7360
Ri185	avI10/avC11	avI10/avC11_h2	   16.5813
Ri186	avI10/avC10_h5	avI10/avC10_h6	   11.5280
Ri187	CLK_h87	CLK_h88	   11.4267
Ri188	avI10/avC11_h3	avI10/avC11_h4	   16.9440
Ri190	GND_h43	GND_h45	    1.6827
Ri191	avI10/avC11_h5	avI10/avC11_h6	   11.5813
Ri192	Q6_h2	Q6_h4	    0.7253
Ri194	Q6_h2	Q6_h6	    1.5280
Ri195	Q6_h1	Q6_h2	   15.0000
Ri196	Q6_h3	Q6_h4	   15.0000
Ri197	avI11/avC9_h2	avI11/avC9_h3	2.667E-02
Ri198	avI11/avC9_h3	avI11/avC9_h4	   15.6987
Ri199	avI11/avC9	avI11/avC9_h2	   15.0000
Ri201	RST_h57	RST_h59	    1.6827
Ri203	Q6_h9	Q6_h11	    1.8907
Ri204	avI11/avC8	avI11/avC8_h2	   16.9440
Ri205	CLK_h92	CLK_h93	   11.4267
Ri206	avI11/avC10	avI11/avC10_h2	   16.6347
Ri207	avI11/avC8_h3	avI11/avC8_h4	   10.2807
Ri208	avI11/avC8_h4	avI11/avC8_h5	   15.1813
Ri209	avI11/avC10_h3	avI11/avC10_h4	   16.8907
Ri210	CLK_h95	CLK_h96	   10.0000
Ri211	CLK_h96	CLK_h97	    1.4267
Ri212	avI11/avC9_h5	avI11/avC9_h6	   11.7360
Ri213	avI11/avC11	avI11/avC11_h2	   16.5813
Ri214	avI11/avC10_h5	avI11/avC10_h6	   11.5280
Ri215	CLK_h101	CLK_h102	   11.4267
Ri216	avI11/avC11_h3	avI11/avC11_h4	   16.9440
Ri218	GND_h50	GND_h52	    1.6827
Ri219	avI11/avC11_h5	avI11/avC11_h6	   11.5813
Ri220	Q7_h2	Q7_h4	    0.7253
Ri222	Q7_h2	Q7_h6	    1.5280
Ri223	Q7_h1	Q7_h2	   15.0000
Ri224	Q7_h3	Q7_h4	   15.0000
Ri225	avI1/avC6	avI1/avC6_h2	   17.0453
Ri226	Q0_h17	Q0_h18	6.133E-02
Ri227	Q0_h18	Q0_h19	    1.6747
Ri228	Q5_h17	Q5_h18	   16.6347
Ri229	avI1/avC6_h3	avI1/avC6_h4	   11.6827
Ri230	Q0_h23	Q0_h24	   16.4267
Ri231	avC14	avC14_h2	   16.7893
Ri232	Q5_h19	Q5_h20	   11.5280
Ri233	avC14_h3	avC14_h4	   15.3013
Ri234	avC14_h4	avC14_h5	    1.4347
Ri235	avI1/avC6_h6	avI1/avC6_h7	   16.4800
Ri236	Q0_h25	Q0_h26	   11.7360
Ri237	Q5_h23	Q5_h24	   15.3600
Ri238	Q5_h24	Q5_h25	    1.5307
Ri239	avI2/avC6	avI2/avC6_h2	   17.0453
Ri240	Q6_h17	Q6_h18	6.133E-02
Ri241	Q6_h18	Q6_h19	    1.6747
Ri242	Q7_h9	Q7_h10	   16.6347
Ri243	avI2/avC6_h3	avI2/avC6_h4	   11.6827
Ri244	Q6_h21	Q6_h22	   16.4267
Ri245	avC15	avC15_h2	   16.7893
Ri246	Q7_h11	Q7_h12	   11.5280
Ri247	avC15_h3	avC15_h4	   15.3013
Ri248	avC15_h4	avC15_h5	    1.4347
Ri249	avI2/avC6_h6	avI2/avC6_h7	   16.4800
Ri250	Q6_h25	Q6_h26	   11.7360
Ri251	Q7_h15	Q7_h16	   15.3600
Ri252	Q7_h16	Q7_h17	    1.5307
Ri253	avI3/avC6	avI3/avC6_h2	   16.8907
Ri254	avC15_h8	avC15_h9	   10.0267
Ri255	avC15_h9	avC15_h10	3.467E-02
Ri256	avI3/avC6_h3	avI3/avC6_h4	   16.6347
Ri257	avI3/avC10	avI3/avC10_h2	   16.4267
Ri258	avI3/avC6_h5	avI3/avC6_h6	   11.5280
Ri259	avC13_h9	avC13_h10	   17.0453
Ri260	avI3/avC7	avI3/avC7_h2	   11.5280
Ri261	avI3/avC10_h3	avI3/avC10_h4	   16.4267
Ri262	avC13_h11	avC13_h12	   15.0453
Ri263	avC13_h12	avC13_h13	    1.4347
Ri264	avC14_h8	avC14_h9	   11.5813
Ri265	avC15_h15	avC15_h16	   11.4267
Ri266	avI3/avC10_h5	avI3/avC10_h6	   15.0267
Ri267	avI3/avC7_h5	avI3/avC7_h6	   16.8907
Ri268	avC14_h12	avC14_h13	6.133E-02
Ri269	avC14_h13	avC14_h14	    1.5200
Ri270	avI3/avC7_h7	avI3/avC7_h8	   16.6347
Ri271	VDD_h1	VDD	   15.4191
Ri272	VDD_h3	VDD	    7.0560
Ri273	VDD_h4	VDD	    6.0480
Ri274	VDD_h5	VDD	    5.3280
Ri275	VDD_h6	VDD	    4.5720
Ri276	VDD_h7	VDD	    3.8160
Ri277	VDD_h8	VDD	    2.9880
Ri278	VDD_h9	VDD	    2.2320
Ri279	VDD_h10	VDD	    1.4040
Ri280	VDD_h11	VDD	    0.6480
Ri281	VDD	VDD_h12	    0.1800
Ri282	VDD	VDD_h13	    0.9360
Ri283	VDD	VDD_h14	    1.7640
Ri284	VDD	VDD_h15	    2.5200
Ri285	VDD	VDD_h16	    3.3480
Ri286	VDD	VDD_h17	    4.1040
Ri287	VDD	VDD_h18	    4.9320
Ri288	VDD	VDD_h19	    5.6880
Ri289	VDD	VDD_h20	    6.5160
Ri290	VDD	VDD_h21	   15.4191
Ri291	VDD	VDD_h22	   15.4191
Ri292	VDD	VDD_h23	   15.4191
Ri293	VDD	VDD_h24	   15.4191
Ri294	VDD	VDD_h25	   15.4191
Ri295	VDD	VDD_h26	   15.4191
Ri296	VDD	VDD_h27	   15.4191
Ri297	VDD	VDD_h28	   15.4191
Ri298	VDD	VDD_h29	   15.4191
Ri299	VDD	VDD_h30	   15.4191
Ri300	VDD	VDD_h31	   15.4191
Ri301	VDD	VDD_h32	   15.4191
Ri302	VDD	VDD_h33	   15.4191
Ri303	VDD	VDD_h34	   15.4191
Ri304	VDD	VDD_h35	   15.4191
Ri305	VDD	VDD_h36	   15.4191
Ri306	VDD	VDD_h37	   15.4191
Ri307	VDD	VDD_h38	   15.4191
Ri308	VDD	VDD_h39	   15.4191
Ri309	VDD	VDD_h40	   15.4191
Ri310	VDD	VDD_h41	   15.4191
Ri311	VDD	VDD_h42	   15.4191
Ri312	VDD	VDD_h43	   15.4191
Ri313	VDD	VDD_h44	   15.4191
Ri314	VDD	VDD_h45	   15.4191
Ri315	VDD	VDD_h46	   15.4191
Ri316	VDD_h20	VDD_h47	   15.4025
Ri317	VDD_h48	VDD	    7.2720
Ri318	VDD	VDD_h49	   15.3462
Ri319	VDD_h2	VDD_h3	    0.8824
Ri320	VDD_h2	VDD_h4	    1.6667
Ri321	VDD_h2	VDD_h5	    1.6667
Ri322	VDD_h2	VDD_h6	    1.5000
Ri323	VDD_h2	VDD_h7	    1.3636
Ri324	VDD_h2	VDD_h8	    1.5000
Ri325	VDD_h2	VDD_h9	    1.3636
Ri326	VDD_h2	VDD_h10	    1.5000
Ri327	VDD_h2	VDD_h11	    1.3636
Ri328	VDD_h2	VDD_h12	    1.5000
Ri329	VDD_h2	VDD_h13	    1.3636
Ri330	VDD_h2	VDD_h14	    1.5000
Ri331	VDD_h2	VDD_h15	    1.3636
Ri332	VDD_h2	VDD_h16	    1.5000
Ri333	VDD_h2	VDD_h17	    1.3636
Ri334	VDD_h2	VDD_h18	    1.5000
Ri335	VDD_h2	VDD_h19	    1.3636
Ri336	VDD_h2	VDD_h20	    1.5000
Ri337	VDD_h2	VDD_h48	    1.3636
Ri338	GND_h57	GND	   15.3551
Ri339	GND_h59	GND	    7.0560
Ri340	GND_h60	GND	    6.0480
Ri341	GND_h61	GND	    5.3280
Ri342	GND	GND_h53	    4.7200
Ri343	GND_h62	GND	    4.5720
Ri344	GND_h63	GND	    3.8160
Ri345	GND_h46	GND	    3.1360
Ri346	GND_h64	GND	    2.9880
Ri347	GND_h65	GND	    2.2320
Ri348	GND_h39	GND	    1.5520
Ri349	GND_h66	GND	    1.4040
Ri350	GND_h67	GND	    0.6480
Ri351	GND	GND_h32	3.200E-02
Ri352	GND	GND_h68	    0.1800
Ri353	GND	GND_h69	    0.9360
Ri354	GND	GND_h25	    1.6160
Ri355	GND	GND_h70	    1.7640
Ri356	GND	GND_h71	    2.5200
Ri357	GND	GND_h18	    3.2000
Ri358	GND	GND_h72	    3.3480
Ri359	GND	GND_h73	    4.1040
Ri360	GND	GND_h11	    4.7840
Ri361	GND	GND_h74	    4.9320
Ri362	GND	GND_h75	    5.6880
Ri363	GND	GND_h76	    6.5160
Ri364	GND	GND_h77	   15.3551
Ri365	GND	GND_h78	   15.3551
Ri366	GND	GND_h79	   15.3551
Ri367	GND	GND_h80	   15.3551
Ri368	GND	GND_h81	   15.3551
Ri369	GND	GND_h82	   15.3551
Ri370	GND	GND_h83	   15.3551
Ri371	GND	GND_h84	   15.3551
Ri372	GND	GND_h85	   15.3551
Ri373	GND	GND_h86	   15.3551
Ri374	GND	GND_h87	   15.3551
Ri375	GND	GND_h88	   15.3551
Ri376	GND	GND_h89	   15.3551
Ri377	GND	GND_h90	   15.3551
Ri378	GND_h32	GND_h91	   15.2719
Ri379	GND	GND_h92	   15.3551
Ri380	GND	GND_h93	   15.3551
Ri381	GND_h25	GND_h94	   15.2719
Ri382	GND	GND_h95	   15.3551
Ri383	GND	GND_h96	   15.3551
Ri384	GND_h18	GND_h97	   15.2719
Ri385	GND	GND_h98	   15.3551
Ri386	GND	GND_h99	   15.3551
Ri387	GND_h11	GND_h100	   15.2719
Ri388	GND	GND_h101	   15.3551
Ri389	GND	GND_h102	   15.3551
Ri390	GND	GND_h103	   15.3551
Ri391	GND_h104	GND	    7.2720
Ri392	GND	GND_h4	    7.6000
Ri393	GND_h4	GND	2.920E-02
Ri394	GND	GND_h105	   15.2822
Ri395	GND_h76	GND_h106	   15.3385
Ri396	GND_h58	GND_h59	    0.8824
Ri397	GND_h58	GND_h60	    1.6667
Ri398	GND_h58	GND_h61	    1.6667
Ri399	GND_h58	GND_h62	    1.5000
Ri400	GND_h58	GND_h63	    1.3636
Ri401	GND_h58	GND_h64	    1.5000
Ri402	GND_h58	GND_h65	    1.3636
Ri403	GND_h58	GND_h66	    1.5000
Ri404	GND_h58	GND_h67	    1.3636
Ri405	GND_h58	GND_h68	    1.5000
Ri406	GND_h58	GND_h69	    1.3636
Ri407	GND_h58	GND_h70	    1.5000
Ri408	GND_h58	GND_h71	    1.3636
Ri409	GND_h58	GND_h72	    1.5000
Ri410	GND_h58	GND_h73	    1.3636
Ri411	GND_h58	GND_h74	    1.5000
Ri412	GND_h58	GND_h75	    1.3636
Ri413	GND_h58	GND_h76	    1.5000
Ri414	GND_h58	GND_h104	    1.3636
Rh1	GND_h3	GND_h4	    1.6806
Rh2	avC13_h3	avC13_h4	    1.4600
Rh3	avI4/avC8_h4	avI4/avC8_h2	    1.6160
Rh4	avI4/avC9_h6	avI4/avC9_h3	    2.5880
Rh5	avI4/avC10_h6	avI4/avC10_h4	    0.5400
Rh6	avI4/avC10_h4	avI4/avC10_h2	    0.2160
Rh7	CLK_h10	CLK_h11	    0.5280
Rh8	CLK_h11	CLK_h6	    0.1200
Rh9	CLK_h6	CLK_h2	    0.4320
Rh10	RST_h4	RST_h3	    1.4600
Rh11	avI4/avC11_h6	avI4/avC11_h4	    0.3240
Rh12	avI4/avC11_h4	avI4/avC11_h2	    0.4320
Rh13	Q0_h6	Q0_h7	    1.5080
Rh14	RST_h11	RST_h13	6.000E-02
Rh15	Q0_h11	Q0_h12	    1.4600
Rh16	avI5/avC8_h4	avI5/avC8_h2	    1.6160
Rh17	avI5/avC9_h6	avI5/avC9_h3	    2.5880
Rh18	avI5/avC10_h6	avI5/avC10_h4	    0.5400
Rh19	avI5/avC10_h4	avI5/avC10_h2	    0.2160
Rh20	CLK_h23	CLK_h24	    0.5280
Rh21	CLK_h24	CLK_h19	    0.1200
Rh22	CLK_h19	CLK_h15	    0.4320
Rh23	GND_h10	GND_h11	    1.6806
Rh24	avI5/avC11_h6	avI5/avC11_h4	    0.3240
Rh25	avI5/avC11_h4	avI5/avC11_h2	    0.4320
Rh26	Q1_h6	Q1_h7	    1.5080
Rh27	RST_h19	RST_h20	    1.4600
Rh28	Q1_h11	Q1_h12	    1.4600
Rh29	avI6/avC8_h4	avI6/avC8_h2	    1.6160
Rh30	avI6/avC9_h6	avI6/avC9_h3	    2.5880
Rh31	avI6/avC10_h6	avI6/avC10_h4	    0.5400
Rh32	avI6/avC10_h4	avI6/avC10_h2	    0.2160
Rh33	CLK_h36	CLK_h37	    0.5280
Rh34	CLK_h37	CLK_h32	    0.1200
Rh35	CLK_h32	CLK_h28	    0.4320
Rh36	GND_h17	GND_h18	    1.6806
Rh37	avI6/avC11_h6	avI6/avC11_h4	    0.3240
Rh38	avI6/avC11_h4	avI6/avC11_h2	    0.4320
Rh39	Q2_h6	Q2_h7	    1.5080
Rh40	RST_h27	RST_h28	    1.4600
Rh41	Q2_h11	Q2_h12	    1.4600
Rh42	avI7/avC8_h4	avI7/avC8_h2	    1.6160
Rh43	avI7/avC9_h6	avI7/avC9_h3	    2.5880
Rh44	avI7/avC10_h6	avI7/avC10_h4	    0.5400
Rh45	avI7/avC10_h4	avI7/avC10_h2	    0.2160
Rh46	CLK_h49	CLK_h50	    0.5280
Rh47	CLK_h50	CLK_h45	    0.1200
Rh48	CLK_h45	CLK_h41	    0.4320
Rh49	GND_h24	GND_h25	    1.6806
Rh50	avI7/avC11_h6	avI7/avC11_h4	    0.3240
Rh51	avI7/avC11_h4	avI7/avC11_h2	    0.4320
Rh52	Q3_h6	Q3_h7	    1.5080
Rh53	RST_h35	RST_h36	    1.4600
Rh54	Q3_h11	Q3_h12	    1.4600
Rh55	avI8/avC8_h4	avI8/avC8_h2	    1.6160
Rh56	avI8/avC9_h6	avI8/avC9_h3	    2.5880
Rh57	avI8/avC10_h6	avI8/avC10_h4	    0.5400
Rh58	avI8/avC10_h4	avI8/avC10_h2	    0.2160
Rh59	CLK_h62	CLK_h63	    0.5280
Rh60	CLK_h63	CLK_h58	    0.1200
Rh61	CLK_h58	CLK_h54	    0.4320
Rh62	GND_h31	GND_h32	    1.6806
Rh63	avI8/avC11_h6	avI8/avC11_h4	    0.3240
Rh64	avI8/avC11_h4	avI8/avC11_h2	    0.4320
Rh65	Q4_h6	Q4_h7	    1.5080
Rh66	RST_h43	RST_h44	    1.4600
Rh67	Q4_h11	Q4_h12	    1.4600
Rh68	avI9/avC8_h4	avI9/avC8_h2	    1.6160
Rh69	avI9/avC9_h6	avI9/avC9_h3	    2.5880
Rh70	avI9/avC10_h6	avI9/avC10_h4	    0.5400
Rh71	avI9/avC10_h4	avI9/avC10_h2	    0.2160
Rh72	CLK_h75	CLK_h76	    0.5280
Rh73	CLK_h76	CLK_h71	    0.1200
Rh74	CLK_h71	CLK_h67	    0.4320
Rh75	GND_h38	GND_h39	    1.6806
Rh76	avI9/avC11_h6	avI9/avC11_h4	    0.3240
Rh77	avI9/avC11_h4	avI9/avC11_h2	    0.4320
Rh78	Q5_h6	Q5_h7	    1.5080
Rh79	RST_h51	RST_h53	6.000E-02
Rh80	Q5_h11	Q5_h12	    1.4600
Rh81	avI10/avC8_h4	avI10/avC8_h2	    1.6160
Rh82	avI10/avC9_h6	avI10/avC9_h3	    2.5880
Rh83	avI10/avC10_h6	avI10/avC10_h4	    0.5400
Rh84	avI10/avC10_h4	avI10/avC10_h2	    0.2160
Rh85	CLK_h88	CLK_h89	    0.5280
Rh86	CLK_h89	CLK_h84	    0.1200
Rh87	CLK_h84	CLK_h80	    0.4320
Rh88	GND_h45	GND_h46	    1.6806
Rh89	avI10/avC11_h6	avI10/avC11_h4	    0.3240
Rh90	avI10/avC11_h4	avI10/avC11_h2	    0.4320
Rh91	Q6_h6	Q6_h7	    1.5080
Rh92	RST_h59	RST_h60	    1.4600
Rh93	Q6_h11	Q6_h12	    1.4600
Rh94	avI11/avC8_h4	avI11/avC8_h2	    1.6160
Rh95	avI11/avC9_h6	avI11/avC9_h3	    2.5880
Rh96	avI11/avC10_h6	avI11/avC10_h4	    0.5400
Rh97	avI11/avC10_h4	avI11/avC10_h2	    0.2160
Rh98	CLK_h102	CLK_h103	    0.5280
Rh99	CLK_h103	CLK_h97	    0.1200
Rh100	CLK_h97	CLK_h93	    0.4320
Rh101	GND_h52	GND_h53	    1.6806
Rh102	avI11/avC11_h6	avI11/avC11_h4	    0.3240
Rh103	avI11/avC11_h4	avI11/avC11_h2	    0.4320
Rh104	Q7_h6	Q7_h7	    1.5080
Rh105	avC14_h5	avC14_h6	    0.1080
Rh106	avC14_h6	avC14_h2	    0.1080
Rh107	avI1/avC6_h7	avI1/avC6_h4	    0.3240
Rh108	avI1/avC6_h4	avI1/avC6_h2	    0.3240
Rh109	Q0_h26	Q0_h23	    0.3240
Rh110	Q0_h23	Q0_h19	    0.3240
Rh113	Q5_h25	Q5_h20	    0.3240
Rh114	Q5_h20	Q5_h18	    0.3240
Rh115	avC15_h5	avC15_h6	    0.1080
Rh116	avC15_h6	avC15_h2	    0.1080
Rh117	avI2/avC6_h7	avI2/avC6_h4	    0.3240
Rh118	avI2/avC6_h4	avI2/avC6_h2	    0.3240
Rh119	Q6_h26	Q6_h21	    0.3240
Rh120	Q6_h21	Q6_h19	    0.3240
Rh123	Q7_h17	Q7_h12	    0.3240
Rh124	Q7_h12	Q7_h10	    0.3240
Rh125	avI3/avC6_h6	avI3/avC6_h4	    0.3240
Rh126	avI3/avC6_h4	avI3/avC6_h2	    0.2160
Rh127	avC13_h13	avC13_h14	    0.1080
Rh128	avC13_h14	avC13_h10	    0.1080
Rh129	avC15_h16	avC15_h14	    1.0800
Rh130	avC15_h14	avC15_h9	    1.4000
Rh131	avI3/avC10_h5	avI3/avC10_h3	    1.8320
Rh132	avI3/avC10_h3	avI3/avC10	    0.4320
Rh133	avC14_h14	avC14_h15	    0.2160
Rh134	avC14_h15	avC14_h9	    0.4320
Rh135	avI3/avC7_h8	avI3/avC7_h6	    0.2160
Rh136	avI3/avC7_h6	avI3/avC7_h2	    0.7560
Rg1	avC13_h4	avC13_h8	    1.6800
Rg2	CLK_h13	CLK_h11	    2.8480
Rg3	RST_h5	RST_h4	    1.4480
Rg4	Q0_h8	Q0_h7	    1.4480
Rg5	RST_h12	RST_h13	    2.8480
Rg6	Q0_h16	Q0_h12	    1.4480
Rg7	CLK_h26	CLK_h24	    2.8480
Rg8	Q1_h8	Q1_h7	    1.4680
Rg9	RST_h21	RST_h20	    1.4480
Rg10	Q1_h16	Q1_h12	    1.4680
Rg11	CLK_h39	CLK_h37	    2.8480
Rg12	Q2_h8	Q2_h7	    1.4680
Rg13	RST_h29	RST_h28	    1.4480
Rg14	Q2_h16	Q2_h12	    1.4680
Rg15	CLK_h52	CLK_h50	    2.8480
Rg16	Q3_h8	Q3_h7	    1.4680
Rg17	RST_h37	RST_h36	    1.4480
Rg18	Q3_h16	Q3_h12	6.800E-02
Rg19	CLK_h65	CLK_h63	    2.8480
Rg20	Q4_h8	Q4_h7	    1.4680
Rg21	RST_h45	RST_h44	    1.4480
Rg22	Q4_h16	Q4_h12	    1.4680
Rg23	CLK_h78	CLK_h76	    2.8480
Rg24	Q5_h7	Q5_h8	    1.5640
Rg25	RST_h52	RST_h53	    2.8480
Rg26	Q5_h12	Q5_h16	    1.5640
Rg27	CLK_h91	CLK_h89	    2.8480
Rg28	Q6_h8	Q6_h7	    1.4680
Rg29	RST_h61	RST_h60	    1.4480
Rg30	Q6_h16	Q6_h12	    1.4680
Rg31	CLK_h100	CLK_h103	    1.4480
Rg32	Q7_h7	Q7_h8	    1.7960
Rg33	Q0_h21	Q0_h19	    2.8680
Rg34	avC14_h6	avC14_h7	    2.9640
Rg35	Q5_h27	Q5_h25	    3.1000
Rg36	Q6_h23	Q6_h19	    2.9840
Rg37	avC15_h7	avC15_h6	    2.9840
Rg38	Q7_h19	Q7_h17	    2.8680
Rg39	avC15_h13	avC15_h14	    2.9840
Rg40	avC13_h15	avC13_h14	    3.1000
Rg41	avC14_h15	avC14_h19	    3.0800
Rf1	Q1_h16	Q1	    0.2938
Rf2	Q1	Q1_h8	    0.2940
Rf3	Q2_h16	Q2	    0.2938
Rf4	Q2	Q2_h8	    0.2940
Rf5	Q3_h16	Q3	    1.6938
Rf6	Q3	Q3_h8	    0.2940
Rf7	Q4_h16	Q4	    0.2938
Rf8	Q4	Q4_h8	    0.2940
Rf9	RST_h61	RST_h52	    2.3760
Rf10	RST_h52	RST_h45	    2.3760
Rf11	RST_h45	RST_h37	    2.3760
Rf12	RST_h37	RST	    0.2638
Rf13	RST	RST_h29	    2.1120
Rf14	RST_h29	RST_h21	    2.3760
Rf15	RST_h21	RST_h12	    2.3760
Rf16	RST_h12	RST_h5	    0.5280
Rf17	CLK_h100	CLK_h91	    3.7760
Rf18	CLK_h91	CLK_h78	    2.3760
Rf19	CLK_h78	CLK_h65	    2.3760
Rf20	CLK_h65	CLK	    1.1878
Rf21	CLK	CLK_h52	    1.1880
Rf22	CLK_h52	CLK_h39	    2.3760
Rf23	CLK_h39	CLK_h26	    2.3760
Rf24	CLK_h26	CLK_h13	    2.3760
Rf25	Q0_h21	Q0	    8.5318
Rf26	Q0	Q0_h16	    7.9440
Rf27	Q0_h16	Q0_h8	    0.5880
Rf28	Q5_h27	Q5	    2.9698
Rf29	Q5	Q5_h16	    2.3820
Rf30	Q5_h16	Q5_h8	    0.5880
Rf31	Q6_h23	Q6	    1.9438
Rf32	Q6	Q6_h16	    1.3560
Rf33	Q6_h16	Q6_h8	    0.5880
Rf34	Q7_h19	Q7	    1.1338
Rf35	Q7	Q7_h8	    1.1340
Rf36	avC15_h13	avC15_h7	    0.6480
Rf37	avC13_h15	avC13_h8	   21.6600
Rf38	avC14_h19	avC14_h7	    3.0240
C1	VDD	GND	2.841E-15
C2	CLK	GND	4.463E-16
C3	Q0	GND	2.206E-15
C4	Q1	GND	9.872E-17
C5	Q2	GND	9.872E-17
C6	Q3	GND	9.872E-17
C7	Q4	GND	9.872E-17
C8	Q5	GND	1.358E-15
C9	Q6	GND	5.559E-16
C10	Q7	GND	5.308E-16
C11	RST	GND	2.251E-16
C12	avC14	GND	1.009E-16
C13	avC15	GND	1.013E-16
C14	avC13	GND	1.870E-16
C15	avI11/avC16	GND	3.269E-17
C16	avI11/avC15	GND	1.268E-17
C17	avI11/avC14	GND	3.772E-18
C18	avI11/avC13	GND	5.006E-18
C19	avI11/avC12	GND	4.978E-18
C20	avI11/avC11	GND	5.884E-17
C21	avI11/avC10	GND	4.187E-17
C22	avI11/avC9	GND	2.720E-19
C23	avI11/avC8	GND	1.031E-16
C24	avI10/avC16	GND	5.269E-17
C25	avI10/avC15	GND	1.683E-17
C26	avI10/avC14	GND	1.652E-17
C27	avI10/avC13	GND	1.499E-17
C28	avI10/avC12	GND	1.158E-17
C29	avI10/avC11	GND	6.764E-17
C30	avI10/avC10	GND	4.703E-17
C31	avI10/avC9	GND	5.035E-19
C32	avI10/avC8	GND	1.100E-16
C33	avI9/avC16	GND	5.613E-17
C34	avI9/avC15	GND	1.792E-17
C35	avI9/avC14	GND	1.652E-17
C36	avI9/avC13	GND	1.499E-17
C37	avI9/avC12	GND	1.158E-17
C38	avI9/avC11	GND	6.514E-17
C39	avI9/avC10	GND	4.703E-17
C40	avI9/avC9	GND	4.452E-19
C41	avI9/avC8	GND	1.100E-16
C42	avI8/avC16	GND	5.726E-17
C43	avI8/avC15	GND	1.792E-17
C44	avI8/avC14	GND	1.652E-17
C45	avI8/avC13	GND	1.499E-17
C46	avI8/avC12	GND	1.158E-17
C47	avI8/avC11	GND	6.478E-17
C48	avI8/avC10	GND	4.703E-17
C49	avI8/avC9	GND	4.452E-19
C50	avI8/avC8	GND	1.100E-16
C51	avI7/avC16	GND	5.727E-17
C52	avI7/avC15	GND	1.792E-17
C53	avI7/avC14	GND	1.652E-17
C54	avI7/avC13	GND	1.509E-17
C55	avI7/avC12	GND	1.158E-17
C56	avI7/avC11	GND	6.478E-17
C57	avI7/avC10	GND	4.703E-17
C58	avI7/avC9	GND	4.452E-19
C59	avI7/avC8	GND	1.100E-16
C60	avI6/avC16	GND	5.727E-17
C61	avI6/avC15	GND	1.796E-17
C62	avI6/avC14	GND	1.652E-17
C63	avI6/avC13	GND	1.499E-17
C64	avI6/avC12	GND	1.158E-17
C65	avI6/avC11	GND	6.477E-17
C66	avI6/avC10	GND	4.703E-17
C67	avI6/avC9	GND	7.612E-19
C68	avI6/avC8	GND	1.100E-16
C69	avI5/avC16	GND	5.727E-17
C70	avI5/avC15	GND	1.788E-17
C71	avI5/avC14	GND	1.652E-17
C72	avI5/avC13	GND	1.499E-17
C73	avI5/avC12	GND	1.158E-17
C74	avI5/avC11	GND	6.479E-17
C75	avI5/avC10	GND	4.700E-17
C76	avI5/avC9	GND	9.452E-19
C77	avI5/avC8	GND	1.099E-16
C78	avI4/avC16	GND	4.264E-17
C79	avI4/avC15	GND	1.361E-17
C80	avI4/avC14	GND	3.772E-18
C81	avI4/avC13	GND	5.006E-18
C82	avI4/avC12	GND	6.648E-21
C83	avI4/avC11	GND	6.704E-17
C84	avI4/avC10	GND	4.209E-17
C85	avI4/avC8	GND	1.011E-16
C86	avI3/avC10	GND	1.330E-16
C87	avI3/avC8	GND	1.232E-17
C88	avI3/avC7	GND	1.068E-16
C89	avI3/avC6	GND	9.271E-17
C90	avI2/avC6	GND	1.292E-16
C91	avI1/avC6	GND	1.332E-16
C92	avC13_h5	GND	4.574E-17
C93	CLK_h3	GND	5.775E-17
C94	CLK_h7	GND	5.821E-17
C95	avI4/avC9_h7	GND	4.163E-17
C96	avI4/avC10_h7	GND	5.283E-17
C97	RST_h6	GND	5.560E-17
C98	avI4/avC11_h7	GND	5.684E-17
C99	RST_h14	GND	5.001E-17
C100	Q0_h13	GND	4.524E-17
C101	CLK_h16	GND	5.790E-17
C102	CLK_h20	GND	5.777E-17
C103	avI5/avC9_h7	GND	4.156E-17
C104	avI5/avC10_h7	GND	5.274E-17
C105	avI5/avC11_h7	GND	5.645E-17
C106	RST_h22	GND	5.114E-17
C107	Q1_h13	GND	4.518E-17
C108	CLK_h29	GND	5.790E-17
C109	CLK_h33	GND	5.777E-17
C110	avI6/avC9_h7	GND	4.156E-17
C111	avI6/avC10_h7	GND	5.274E-17
C112	avI6/avC11_h7	GND	5.645E-17
C113	RST_h30	GND	5.098E-17
C114	Q2_h13	GND	4.518E-17
C115	CLK_h42	GND	5.789E-17
C116	CLK_h46	GND	5.774E-17
C117	avI7/avC9_h7	GND	4.156E-17
C118	avI7/avC10_h7	GND	5.274E-17
C119	avI7/avC11_h7	GND	5.645E-17
C120	RST_h38	GND	5.098E-17
C121	Q3_h13	GND	4.518E-17
C122	CLK_h55	GND	5.789E-17
C123	CLK_h59	GND	5.774E-17
C124	avI8/avC9_h7	GND	4.156E-17
C125	avI8/avC10_h7	GND	5.274E-17
C126	avI8/avC11_h7	GND	5.645E-17
C127	RST_h46	GND	5.098E-17
C128	Q4_h13	GND	4.518E-17
C129	CLK_h68	GND	5.789E-17
C130	CLK_h72	GND	5.774E-17
C131	avI9/avC9_h7	GND	4.156E-17
C132	avI9/avC10_h7	GND	5.274E-17
C133	avI9/avC11_h7	GND	6.029E-17
C134	RST_h54	GND	4.949E-17
C135	Q5_h13	GND	4.552E-17
C136	CLK_h81	GND	5.707E-17
C137	CLK_h85	GND	5.764E-17
C138	avI10/avC9_h7	GND	4.154E-17
C139	avI10/avC10_h7	GND	5.272E-17
C140	avI10/avC11_h7	GND	5.704E-17
C141	RST_h62	GND	5.115E-17
C142	Q6_h13	GND	4.480E-17
C143	CLK_h94	GND	5.730E-17
C144	CLK_h98	GND	5.965E-17
C145	avI11/avC9_h7	GND	4.183E-17
C146	avI11/avC10_h7	GND	5.464E-17
C147	avI11/avC11_h7	GND	5.745E-17
C148	Q0_h20	GND	6.296E-17
C149	Q5_h21	GND	6.814E-17
C150	Q0_h27	GND	5.087E-17
C151	Q6_h20	GND	6.161E-17
C152	Q7_h13	GND	6.960E-17
C153	Q6_h27	GND	5.182E-17
C154	avC15_h11	GND	5.764E-17
C155	avI3/avC6_h7	GND	6.544E-17
C156	avI3/avC7_h3	GND	6.491E-17
C157	avC14_h10	GND	5.814E-17
C158	avC15_h17	GND	6.887E-17
C159	avC14_h16	GND	6.493E-17
C160	avC13_h7	GND	5.863E-17
C161	avI4/avC8_h6	GND	5.697E-17
C162	CLK_h8	GND	5.718E-17
C163	avI4/avC9_h8	GND	5.605E-17
C164	avI4/avC10_h8	GND	4.838E-17
C165	CLK_h12	GND	5.640E-17
C166	RST_h8	GND	4.873E-17
C167	avI4/avC11_h8	GND	6.231E-17
C168	RST_h16	GND	4.887E-17
C169	Q0_h15	GND	5.745E-17
C170	avI5/avC8_h6	GND	5.775E-17
C171	CLK_h21	GND	5.633E-17
C172	avI5/avC9_h8	GND	5.402E-17
C173	avI5/avC10_h8	GND	4.869E-17
C174	CLK_h25	GND	5.505E-17
C175	avI5/avC11_h8	GND	6.245E-17
C176	RST_h24	GND	4.901E-17
C177	Q1_h15	GND	5.745E-17
C178	avI6/avC8_h6	GND	5.775E-17
C179	CLK_h34	GND	5.633E-17
C180	avI6/avC9_h8	GND	5.402E-17
C181	avI6/avC10_h8	GND	4.869E-17
C182	CLK_h38	GND	5.505E-17
C183	avI6/avC11_h8	GND	6.245E-17
C184	RST_h32	GND	4.901E-17
C185	Q2_h15	GND	5.745E-17
C186	avI7/avC8_h6	GND	5.775E-17
C187	CLK_h47	GND	5.633E-17
C188	avI7/avC9_h8	GND	5.402E-17
C189	avI7/avC10_h8	GND	4.869E-17
C190	CLK_h51	GND	5.505E-17
C191	avI7/avC11_h8	GND	6.245E-17
C192	RST_h40	GND	4.901E-17
C193	Q3_h15	GND	5.745E-17
C194	avI8/avC8_h6	GND	5.775E-17
C195	CLK_h60	GND	5.633E-17
C196	avI8/avC9_h8	GND	5.402E-17
C197	avI8/avC10_h8	GND	4.869E-17
C198	CLK_h64	GND	5.505E-17
C199	avI8/avC11_h8	GND	6.245E-17
C200	RST_h48	GND	4.901E-17
C201	Q4_h15	GND	5.745E-17
C202	avI9/avC8_h6	GND	5.775E-17
C203	CLK_h73	GND	5.633E-17
C204	avI9/avC9_h8	GND	5.402E-17
C205	avI9/avC10_h8	GND	4.869E-17
C206	CLK_h77	GND	5.505E-17
C207	avI9/avC11_h8	GND	6.245E-17
C208	RST_h56	GND	4.901E-17
C209	Q5_h15	GND	5.745E-17
C210	avI10/avC8_h6	GND	5.775E-17
C211	CLK_h86	GND	5.633E-17
C212	avI10/avC9_h8	GND	5.402E-17
C213	avI10/avC10_h8	GND	4.869E-17
C214	CLK_h90	GND	5.505E-17
C215	avI10/avC11_h8	GND	6.245E-17
C216	RST_h64	GND	4.904E-17
C217	Q6_h15	GND	5.752E-17
C218	avI11/avC8_h6	GND	5.912E-17
C219	CLK_h99	GND	5.718E-17
C220	avI11/avC9_h8	GND	5.475E-17
C221	avI11/avC10_h8	GND	4.845E-17
C222	CLK_h104	GND	5.615E-17
C223	avI11/avC11_h8	GND	6.439E-17
C224	avI1/avC6_h5	GND	4.636E-17
C225	Q5_h22	GND	6.022E-17
C226	Q0_h28	GND	5.911E-17
C227	avI2/avC6_h5	GND	4.604E-17
C228	Q7_h14	GND	6.128E-17
C229	Q6_h28	GND	5.793E-17
C230	avC15_h12	GND	5.807E-17
C231	avI3/avC6_h8	GND	5.486E-17
C232	avI3/avC7_h4	GND	5.254E-17
C233	avC14_h11	GND	5.727E-17
C234	avC15_h18	GND	5.793E-17
C235	avC14_h18	GND	5.733E-17
C236	avC13_h4	GND	7.803E-17
C237	CLK_h11	GND	1.457E-16
C238	RST_h4	GND	2.029E-17
C239	Q0_h7	GND	3.920E-17
C240	RST_h13	GND	1.837E-17
C241	Q0_h12	GND	3.857E-17
C242	CLK_h24	GND	1.465E-16
C243	Q1_h7	GND	6.890E-17
C244	RST_h20	GND	2.108E-17
C245	Q1_h12	GND	5.750E-17
C246	CLK_h37	GND	1.465E-16
C247	Q2_h7	GND	6.728E-17
C248	RST_h28	GND	2.105E-17
C249	Q2_h12	GND	5.750E-17
C250	CLK_h50	GND	1.463E-16
C251	Q3_h7	GND	6.890E-17
C252	RST_h36	GND	2.105E-17
C253	Q3_h12	GND	5.750E-17
C254	CLK_h63	GND	1.463E-16
C255	Q4_h7	GND	6.890E-17
C256	RST_h44	GND	2.105E-17
C257	Q4_h12	GND	5.750E-17
C258	CLK_h76	GND	1.463E-16
C259	Q5_h7	GND	6.233E-17
C260	RST_h53	GND	2.096E-17
C261	Q5_h12	GND	6.424E-17
C262	CLK_h89	GND	1.459E-16
C263	Q6_h7	GND	7.125E-17
C264	RST_h60	GND	2.108E-17
C265	Q6_h12	GND	5.904E-17
C266	CLK_h103	GND	1.506E-16
C267	Q7_h7	GND	8.668E-17
C268	avC14_h6	GND	7.901E-17
C269	avC15_h6	GND	7.789E-17
C270	avC15_h14	GND	2.739E-16
C271	avC13_h14	GND	8.018E-17
C272	avC14_h15	GND	1.477E-16
C273	CLK_h1	GND	4.601E-17
C274	avI4/avC8_h3	GND	1.507E-16
C275	CLK_h4	GND	5.206E-17
C276	avI4/avC9_h5	GND	1.411E-16
C277	avI4/avC10_h5	GND	1.080E-16
C278	CLK_h9	GND	4.453E-17
C279	RST_h1	GND	1.584E-16
C280	avI4/avC11_h5	GND	1.347E-16
C281	RST_h9	GND	1.638E-16
C282	Q0_h9	GND	1.893E-16
C283	CLK_h14	GND	4.639E-17
C284	avI5/avC8_h3	GND	1.495E-16
C285	CLK_h17	GND	5.268E-17
C286	avI5/avC9_h5	GND	1.396E-16
C287	avI5/avC10_h5	GND	1.080E-16
C288	CLK_h22	GND	4.453E-17
C289	avI5/avC11_h5	GND	1.348E-16
C290	RST_h17	GND	1.639E-16
C291	Q1_h9	GND	1.894E-16
C292	CLK_h27	GND	4.639E-17
C293	avI6/avC8_h3	GND	1.495E-16
C294	CLK_h30	GND	5.268E-17
C295	avI6/avC9_h5	GND	1.396E-16
C296	avI6/avC10_h5	GND	1.080E-16
C297	CLK_h35	GND	4.453E-17
C298	avI6/avC11_h5	GND	1.348E-16
C299	RST_h25	GND	1.639E-16
C300	Q2_h9	GND	1.894E-16
C301	CLK_h40	GND	4.639E-17
C302	avI7/avC8_h3	GND	1.495E-16
C303	CLK_h43	GND	5.268E-17
C304	avI7/avC9_h5	GND	1.396E-16
C305	avI7/avC10_h5	GND	1.080E-16
C306	CLK_h48	GND	4.453E-17
C307	avI7/avC11_h5	GND	1.348E-16
C308	RST_h33	GND	1.639E-16
C309	Q3_h9	GND	1.894E-16
C310	CLK_h53	GND	4.639E-17
C311	avI8/avC8_h3	GND	1.495E-16
C312	CLK_h56	GND	5.268E-17
C313	avI8/avC9_h5	GND	1.396E-16
C314	avI8/avC10_h5	GND	1.079E-16
C315	CLK_h61	GND	4.453E-17
C316	avI8/avC11_h5	GND	1.348E-16
C317	RST_h41	GND	1.639E-16
C318	Q4_h9	GND	1.894E-16
C319	CLK_h66	GND	4.639E-17
C320	avI9/avC8_h3	GND	1.495E-16
C321	CLK_h69	GND	5.268E-17
C322	avI9/avC9_h5	GND	1.396E-16
C323	avI9/avC10_h5	GND	1.080E-16
C324	CLK_h74	GND	4.453E-17
C325	avI9/avC11_h5	GND	1.346E-16
C326	RST_h49	GND	1.640E-16
C327	Q5_h9	GND	1.891E-16
C328	CLK_h79	GND	4.637E-17
C329	avI10/avC8_h3	GND	1.495E-16
C330	CLK_h82	GND	5.268E-17
C331	avI10/avC9_h5	GND	1.400E-16
C332	avI10/avC10_h5	GND	1.080E-16
C333	CLK_h87	GND	4.453E-17
C334	avI10/avC11_h5	GND	1.348E-16
C335	RST_h57	GND	1.658E-16
C336	Q6_h9	GND	1.933E-16
C337	CLK_h92	GND	4.646E-17
C338	avI11/avC8_h3	GND	1.521E-16
C339	CLK_h95	GND	5.268E-17
C340	avI11/avC9_h5	GND	1.426E-16
C341	avI11/avC10_h5	GND	1.106E-16
C342	CLK_h101	GND	4.436E-17
C343	avI11/avC11_h5	GND	1.375E-16
C344	Q0_h17	GND	5.582E-17
C345	avI1/avC6_h3	GND	1.429E-16
C346	Q5_h19	GND	1.264E-16
C347	Q0_h25	GND	1.786E-16
C348	Q6_h17	GND	5.512E-17
C349	avI2/avC6_h3	GND	1.431E-16
C350	Q7_h11	GND	1.265E-16
C351	Q6_h25	GND	1.817E-16
C352	avC15_h8	GND	6.717E-17
C353	avI3/avC6_h5	GND	1.019E-16
C354	avC14_h8	GND	9.762E-17
C355	avC15_h15	GND	5.450E-17
C356	avC14_h12	GND	6.323E-17
C357	avC13_h8	GND	3.864E-15
C358	CLK_h13	GND	4.834E-16
C359	RST_h5	GND	9.886E-17
C360	Q0_h8	GND	9.904E-17
C361	RST_h12	GND	2.902E-16
C362	Q0_h16	GND	1.032E-15
C363	CLK_h26	GND	9.147E-16
C364	Q1_h8	GND	9.001E-17
C365	RST_h21	GND	4.752E-16
C366	Q1_h16	GND	8.953E-17
C367	CLK_h39	GND	9.143E-16
C368	Q2_h8	GND	9.001E-17
C369	RST_h29	GND	4.500E-16
C370	Q2_h16	GND	8.953E-17
C371	CLK_h52	GND	6.901E-16
C372	Q3_h8	GND	9.001E-17
C373	RST_h37	GND	2.752E-16
C374	Q3_h16	GND	8.953E-17
C375	CLK_h65	GND	6.917E-16
C376	Q4_h8	GND	9.001E-17
C377	RST_h45	GND	4.751E-16
C378	Q4_h16	GND	8.953E-17
C379	CLK_h78	GND	9.120E-16
C380	Q5_h8	GND	2.120E-16
C381	RST_h52	GND	4.760E-16
C382	Q5_h16	GND	7.796E-16
C383	CLK_h91	GND	9.156E-16
C384	Q6_h8	GND	1.392E-16
C385	RST_h61	GND	2.812E-16
C386	Q6_h16	GND	3.346E-16
C387	CLK_h100	GND	4.599E-16
C388	Q7_h8	GND	2.614E-16
C389	Q0_h21	GND	2.008E-15
C390	avC14_h7	GND	5.776E-16
C391	Q5_h27	GND	7.445E-16
C392	Q6_h23	GND	2.176E-16
C393	avC15_h7	GND	1.591E-16
C394	Q7_h19	GND	3.551E-16
C395	avC15_h13	GND	1.632E-16
C396	avC13_h15	GND	4.704E-15
C397	avC14_h19	GND	3.032E-16
C398	avI4/avC9_h3	GND	3.333E-16
C399	avC13_h3	GND	1.569E-16
C400	avI4/avC8_h2	GND	2.383E-16
C401	CLK_h2	GND	2.804E-16
C402	avI4/avC10_h2	GND	1.477E-16
C403	avI4/avC8_h4	GND	2.349E-16
C404	avI4/avC10_h4	GND	2.848E-16
C405	CLK_h6	GND	1.181E-16
C406	avI4/avC9_h6	GND	2.795E-16
C407	avI4/avC11_h2	GND	1.748E-16
C408	avI4/avC10_h6	GND	1.573E-16
C409	CLK_h10	GND	2.363E-16
C410	avI4/avC11_h4	GND	2.341E-16
C411	RST_h3	GND	1.018E-16
C412	avI4/avC11_h6	GND	1.135E-16
C413	Q0_h6	GND	6.049E-17
C414	avI5/avC9_h3	GND	3.496E-16
C415	RST_h11	GND	9.133E-17
C416	Q0_h11	GND	1.498E-16
C417	avI5/avC8_h2	GND	2.326E-16
C418	CLK_h15	GND	2.646E-16
C419	avI5/avC10_h2	GND	1.487E-16
C420	avI5/avC8_h4	GND	2.346E-16
C421	avI5/avC10_h4	GND	2.721E-16
C422	CLK_h19	GND	1.121E-16
C423	avI5/avC9_h6	GND	2.844E-16
C424	avI5/avC11_h2	GND	1.727E-16
C425	avI5/avC10_h6	GND	1.492E-16
C426	CLK_h23	GND	2.380E-16
C427	avI5/avC11_h4	GND	2.356E-16
C428	avI5/avC11_h6	GND	1.115E-16
C429	Q1_h6	GND	5.991E-17
C430	avI6/avC9_h3	GND	3.407E-16
C431	RST_h19	GND	9.148E-17
C432	Q1_h11	GND	1.532E-16
C433	avI6/avC8_h2	GND	2.326E-16
C434	CLK_h28	GND	2.646E-16
C435	avI6/avC10_h2	GND	1.487E-16
C436	avI6/avC8_h4	GND	2.346E-16
C437	avI6/avC10_h4	GND	2.721E-16
C438	CLK_h32	GND	1.121E-16
C439	avI6/avC9_h6	GND	2.844E-16
C440	avI6/avC11_h2	GND	1.727E-16
C441	avI6/avC10_h6	GND	1.492E-16
C442	CLK_h36	GND	2.380E-16
C443	avI6/avC11_h4	GND	2.355E-16
C444	avI6/avC11_h6	GND	1.114E-16
C445	Q2_h6	GND	5.991E-17
C446	avI7/avC9_h3	GND	3.386E-16
C447	RST_h27	GND	9.144E-17
C448	Q2_h11	GND	1.532E-16
C449	avI7/avC8_h2	GND	2.324E-16
C450	CLK_h41	GND	2.646E-16
C451	avI7/avC10_h2	GND	1.487E-16
C452	avI7/avC8_h4	GND	2.344E-16
C453	avI7/avC10_h4	GND	2.720E-16
C454	CLK_h45	GND	1.118E-16
C455	avI7/avC9_h6	GND	2.824E-16
C456	avI7/avC11_h2	GND	1.721E-16
C457	avI7/avC10_h6	GND	1.497E-16
C458	CLK_h49	GND	2.379E-16
C459	avI7/avC11_h4	GND	2.344E-16
C460	avI7/avC11_h6	GND	1.114E-16
C461	Q3_h6	GND	5.991E-17
C462	avI8/avC9_h3	GND	3.386E-16
C463	RST_h35	GND	9.144E-17
C464	Q3_h11	GND	1.532E-16
C465	avI8/avC8_h2	GND	2.324E-16
C466	CLK_h54	GND	2.645E-16
C467	avI8/avC10_h2	GND	1.487E-16
C468	avI8/avC8_h4	GND	2.344E-16
C469	avI8/avC10_h4	GND	2.721E-16
C470	CLK_h58	GND	1.118E-16
C471	avI8/avC9_h6	GND	2.824E-16
C472	avI8/avC11_h2	GND	1.721E-16
C473	avI8/avC10_h6	GND	1.492E-16
C474	CLK_h62	GND	2.362E-16
C475	avI8/avC11_h4	GND	2.333E-16
C476	avI8/avC11_h6	GND	1.114E-16
C477	Q4_h6	GND	5.991E-17
C478	avI9/avC9_h3	GND	3.386E-16
C479	RST_h43	GND	9.144E-17
C480	Q4_h11	GND	1.532E-16
C481	avI9/avC8_h2	GND	2.324E-16
C482	CLK_h67	GND	2.646E-16
C483	avI9/avC10_h2	GND	1.487E-16
C484	avI9/avC8_h4	GND	2.344E-16
C485	avI9/avC10_h4	GND	2.721E-16
C486	CLK_h71	GND	1.118E-16
C487	avI9/avC9_h6	GND	2.852E-16
C488	avI9/avC11_h2	GND	1.722E-16
C489	avI9/avC10_h6	GND	1.492E-16
C490	CLK_h75	GND	2.380E-16
C491	avI9/avC11_h4	GND	2.352E-16
C492	avI9/avC11_h6	GND	1.177E-16
C493	Q5_h6	GND	6.406E-17
C494	avI10/avC9_h3	GND	3.560E-16
C495	RST_h51	GND	9.113E-17
C496	Q5_h11	GND	1.566E-16
C497	avI10/avC8_h2	GND	2.345E-16
C498	CLK_h80	GND	2.645E-16
C499	avI10/avC10_h2	GND	1.487E-16
C500	avI10/avC8_h4	GND	2.331E-16
C501	avI10/avC10_h4	GND	2.721E-16
C502	CLK_h84	GND	1.112E-16
C503	avI10/avC9_h6	GND	2.872E-16
C504	avI10/avC11_h2	GND	1.741E-16
C505	avI10/avC10_h6	GND	1.492E-16
C506	CLK_h88	GND	2.380E-16
C507	avI10/avC11_h4	GND	2.394E-16
C508	avI10/avC11_h6	GND	1.124E-16
C509	Q6_h6	GND	5.997E-17
C510	avI11/avC9_h3	GND	3.461E-16
C511	RST_h59	GND	9.913E-17
C512	Q6_h11	GND	1.490E-16
C513	avI11/avC8_h2	GND	2.305E-16
C514	CLK_h93	GND	2.638E-16
C515	avI11/avC10_h2	GND	1.505E-16
C516	avI11/avC8_h4	GND	2.335E-16
C517	avI11/avC10_h4	GND	2.834E-16
C518	CLK_h97	GND	1.104E-16
C519	avI11/avC9_h6	GND	2.912E-16
C520	avI11/avC11_h2	GND	1.753E-16
C521	avI11/avC10_h6	GND	1.574E-16
C522	CLK_h102	GND	2.529E-16
C523	avI11/avC11_h4	GND	2.390E-16
C524	avI11/avC11_h6	GND	1.130E-16
C525	Q7_h6	GND	6.716E-17
C526	avI1/avC6_h2	GND	1.711E-16
C527	Q0_h19	GND	1.425E-16
C528	Q5_h18	GND	1.757E-16
C529	avI1/avC6_h4	GND	2.021E-16
C530	avC14_h2	GND	1.810E-16
C531	Q0_h23	GND	1.336E-16
C532	Q5_h20	GND	2.461E-16
C533	avI1/avC6_h7	GND	1.551E-16
C534	avC14_h5	GND	5.883E-17
C535	Q0_h26	GND	1.583E-16
C536	Q5_h25	GND	1.291E-16
C537	avI2/avC6_h2	GND	1.711E-16
C538	Q6_h19	GND	1.412E-16
C539	Q7_h10	GND	1.760E-16
C540	avI2/avC6_h4	GND	2.048E-16
C541	avC15_h2	GND	1.803E-16
C542	Q6_h21	GND	1.321E-16
C543	Q7_h12	GND	2.402E-16
C544	avI2/avC6_h7	GND	1.304E-16
C545	avC15_h5	GND	5.903E-17
C546	Q6_h26	GND	1.548E-16
C547	Q7_h17	GND	9.100E-17
C548	avI3/avC6_h2	GND	1.501E-16
C549	avI3/avC6_h4	GND	1.351E-16
C550	avI3/avC6_h6	GND	1.357E-16
C551	avC13_h10	GND	1.777E-16
C552	avI3/avC7_h2	GND	2.778E-16
C553	avC13_h13	GND	4.360E-17
C554	avI3/avC10_h3	GND	2.009E-16
C555	avC14_h9	GND	2.106E-16
C556	avC15_h16	GND	3.821E-16
C557	avI3/avC10_h5	GND	1.693E-16
C558	avI3/avC7_h6	GND	2.266E-16
C559	avC14_h14	GND	8.330E-17
C560	avI3/avC7_h8	GND	7.826E-17
C561	VDD_h2	GND	4.329E-15
C562	VDD_h49	GND	8.935E-17
C563	avI4/avC8_h5	GND	4.209E-17
C564	avI4/avC10_h3	GND	1.123E-16
C565	VDD_h47	GND	7.488E-17
C566	VDD_h46	GND	5.775E-17
C567	Q0_h1	GND	1.157E-16
C568	VDD_h45	GND	8.664E-17
C569	avI5/avC8_h5	GND	5.143E-17
C570	avI5/avC10_h3	GND	1.158E-16
C571	VDD_h44	GND	7.982E-17
C572	VDD_h43	GND	6.239E-17
C573	Q1_h1	GND	1.186E-16
C574	VDD_h42	GND	8.421E-17
C575	avI6/avC8_h5	GND	5.122E-17
C576	avI6/avC10_h3	GND	1.157E-16
C577	VDD_h41	GND	7.979E-17
C578	VDD_h40	GND	6.223E-17
C579	Q2_h1	GND	1.186E-16
C580	VDD_h39	GND	8.387E-17
C581	avI7/avC8_h5	GND	5.114E-17
C582	avI7/avC10_h3	GND	1.156E-16
C583	VDD_h38	GND	7.969E-17
C584	VDD_h37	GND	6.239E-17
C585	Q3_h1	GND	1.186E-16
C586	VDD_h36	GND	8.387E-17
C587	avI8/avC8_h5	GND	5.114E-17
C588	avI8/avC10_h3	GND	1.156E-16
C589	VDD_h35	GND	7.969E-17
C590	VDD_h34	GND	6.239E-17
C591	Q4_h1	GND	1.186E-16
C592	VDD_h33	GND	8.387E-17
C593	avI9/avC8_h5	GND	5.114E-17
C594	avI9/avC10_h3	GND	1.156E-16
C595	VDD_h32	GND	7.969E-17
C596	VDD_h31	GND	6.119E-17
C597	Q5_h1	GND	1.166E-16
C598	VDD_h30	GND	8.665E-17
C599	avI10/avC8_h5	GND	4.865E-17
C600	avI10/avC10_h3	GND	1.167E-16
C601	VDD_h29	GND	7.898E-17
C602	VDD_h28	GND	6.134E-17
C603	Q6_h1	GND	1.178E-16
C604	VDD_h27	GND	8.325E-17
C605	avI11/avC8_h5	GND	4.199E-17
C606	avI11/avC10_h3	GND	1.089E-16
C607	VDD_h26	GND	7.442E-17
C608	VDD_h25	GND	5.375E-17
C609	Q7_h1	GND	1.128E-16
C610	VDD_h24	GND	7.111E-17
C611	avC14_h3	GND	7.722E-17
C612	Q5_h23	GND	7.718E-17
C613	VDD_h23	GND	6.626E-17
C614	Q6_h22	GND	6.615E-21
C615	avC15_h3	GND	7.861E-17
C616	Q7_h15	GND	8.524E-17
C617	VDD_h22	GND	5.440E-17
C618	avC13_h9	GND	1.145E-16
C619	avI3/avC10_h4	GND	1.038E-18
C620	VDD_h21	GND	6.504E-17
C621	avI3/avC10_h6	GND	7.398E-19
C622	avI3/avC7_h5	GND	1.071E-16
C623	VDD_h1	GND	3.265E-17
C624	avI4/avC9_h4	GND	1.286E-16
C625	avI4/avC11_h3	GND	1.304E-16
C626	Q0_h3	GND	5.903E-18
C627	avI5/avC9_h4	GND	1.424E-16
C628	avI5/avC11_h3	GND	1.319E-16
C629	Q1_h3	GND	5.903E-18
C630	avI6/avC9_h4	GND	1.439E-16
C631	avI6/avC11_h3	GND	1.319E-16
C632	Q2_h3	GND	5.903E-18
C633	avI7/avC9_h4	GND	1.439E-16
C634	avI7/avC11_h3	GND	1.318E-16
C635	Q3_h3	GND	5.903E-18
C636	avI8/avC9_h4	GND	1.439E-16
C637	avI8/avC11_h3	GND	1.319E-16
C638	Q4_h3	GND	5.903E-18
C639	avI9/avC9_h4	GND	1.439E-16
C640	avI9/avC11_h3	GND	1.319E-16
C641	Q5_h3	GND	5.903E-18
C642	avI10/avC9_h4	GND	1.439E-16
C643	avI10/avC11_h3	GND	1.319E-16
C644	Q6_h3	GND	5.903E-18
C645	avI11/avC9_h4	GND	1.439E-16
C646	avI11/avC11_h3	GND	1.304E-16
C647	Q5_h17	GND	7.719E-17
C648	avI1/avC6_h6	GND	4.140E-17
C649	Q7_h9	GND	7.806E-17
C650	avI2/avC6_h6	GND	4.140E-17
C651	avI3/avC6_h3	GND	4.240E-17
C652	avC13_h11	GND	7.852E-17
C653	avI3/avC7_h7	GND	3.450E-17
C654	CLK_h5	GND	9.683E-17
C655	CLK_h18	GND	9.459E-17
C656	CLK_h31	GND	9.459E-17
C657	CLK_h44	GND	9.459E-17
C658	CLK_h57	GND	9.459E-17
C659	CLK_h70	GND	9.459E-17
C660	CLK_h83	GND	9.459E-17
C661	CLK_h96	GND	9.490E-17
C662	Q0_h18	GND	9.903E-17
C663	avC14_h4	GND	1.160E-16
C664	Q5_h24	GND	8.266E-17
C665	Q6_h18	GND	9.611E-17
C666	avC15_h4	GND	1.161E-16
C667	Q7_h16	GND	8.712E-17
C668	avC15_h10	GND	1.026E-16
C669	avC14_h13	GND	7.427E-17
C670	Q0_h4	GND	1.283E-16
C671	Q1_h4	GND	1.294E-16
C672	Q2_h4	GND	1.294E-16
C673	Q3_h4	GND	1.294E-16
C674	Q4_h4	GND	1.294E-16
C675	Q5_h4	GND	1.294E-16
C676	Q6_h4	GND	1.294E-16
C677	Q7_h4	GND	1.228E-16
.ENDS TSPC_LFSR_8bit_RCX
simulator lang=spectre
subckt TSPC_LFSR_8bit CLK RST Q0 Q1 Q2 Q3 Q4 Q5 Q6 Q7 VDD GND
    XR (VDD GND CLK Q0 Q1 Q2 Q3 Q4 Q5 Q6 Q7 RST) TSPC_LFSR_8bit_RCX
ends TSPC_LFSR_8bit
