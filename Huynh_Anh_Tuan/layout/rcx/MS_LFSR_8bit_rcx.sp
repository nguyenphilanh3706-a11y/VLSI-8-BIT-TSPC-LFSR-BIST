*
*
*
*                       LINUX           Sat Nov 21 19:31:41 2026
*
*
*
*  PROGRAM  advgen
*
*  HSPICE LIBRARY
*
*
*

*
.SUBCKT MS_LFSR_8bit VDD GND CLK Q0 Q1 Q2 Q3 Q4 Q5 Q6 Q7 RST
*
*
*  caps2d version: 10
*
*
*       TRANSISTOR CARDS
*
*
MavI12/avD1_1	avI12/avC11	CLK#113	avI12/avC9#9	GND#119
+ nmos1v	L=0.1U	W=0.24U
+ AD=0.0528P	AS=0.0468P	PD=0.68U	PS=0.68U
+ simW=2.4e-07 fw=2.4e-07
MavI12/avD1_2	avI12/avC13	avC13#111	avI12/avC11	GND#119
+ nmos1v	L=0.1U	W=0.24U
+ AD=0.0816P	AS=0.0528P	PD=1.16U	PS=0.68U
+ simW=2.4e-07 fw=2.4e-07
MavI12/avD1_3	GND#145	GND#116	avI12/avC13#5	GND#119
+ nmos1v	L=0.1U	W=0.12U
+ AD=0.0408P	AS=0.0696P	PD=0.68U	PS=1.16U
+ simW=1.2e-07 fw=1.2e-07
MavI12/avD1_4	avI12/avC13#8	Q7#8	GND#145	GND#119	nmos1v
+ L=0.1U	W=0.12U
+ AD=0.0696P	AS=0.0408P	PD=1.16U	PS=0.68U
+ simW=1.2e-07 fw=1.2e-07
MavI12/avD1_5	GND#144	avI12/avC11#8	Q7#3	GND#119	nmos1v
+ L=0.1U	W=0.12U
+ AD=0.0408P	AS=0.0696P	PD=0.68U	PS=1.16U
+ simW=1.2e-07 fw=1.2e-07
MavI12/avD1_6	Q7#11	RST#96	GND#144	GND#119	nmos1v	L=0.1U
+ W=0.12U
+ AD=0.0696P	AS=0.0408P	PD=1.16U	PS=0.68U
+ simW=1.2e-07 fw=1.2e-07
MavI12/avD1_7	avI12/avC10	avC13#101	Q6#13	GND#119	nmos1v
+ L=0.1U	W=0.24U
+ AD=0.0528P	AS=0.0816P	PD=0.68U	PS=1.16U
+ simW=2.4e-07 fw=2.4e-07
MavI12/avD1_8	avI12/avC12	CLK#107	avI12/avC10	GND#119
+ nmos1v	L=0.1U	W=0.24U
+ AD=0.0816P	AS=0.0528P	PD=1.16U	PS=0.68U
+ simW=2.4e-07 fw=2.4e-07
MavI12/avD1_9	GND#147	RST#90	avI12/avC12#5	GND#119	nmos1v
+ L=0.1U	W=0.12U
+ AD=0.0408P	AS=0.0696P	PD=0.68U	PS=1.16U
+ simW=1.2e-07 fw=1.2e-07
MavI12/avD1_10	avI12/avC12#8	avI12/avC9#6	GND#147	GND#119
+ nmos1v	L=0.1U	W=0.12U
+ AD=0.0696P	AS=0.0408P	PD=1.16U	PS=0.68U
+ simW=1.2e-07 fw=1.2e-07
MavI12/avD1_11	GND#146	avI12/avC10#8	avI12/avC9#3	GND#119
+ nmos1v	L=0.1U	W=0.12U
+ AD=0.0408P	AS=0.0696P	PD=0.68U	PS=1.16U
+ simW=1.2e-07 fw=1.2e-07
MavI12/avD1_12	avI12/avC9#9	GND#108	GND#146	GND#119
+ nmos1v	L=0.1U	W=0.12U
+ AD=0.0468P	AS=0.0408P	PD=0.68U	PS=0.68U
+ simW=1.2e-07 fw=1.2e-07
MavI11/avD1_1	avI11/avC11	CLK#100	avI11/avC9#9	GND#119
+ nmos1v	L=0.1U	W=0.24U
+ AD=0.0528P	AS=0.0468P	PD=0.68U	PS=0.68U
+ simW=2.4e-07 fw=2.4e-07
MavI11/avD1_2	avI11/avC13	avC13#98	avI11/avC11	GND#119
+ nmos1v	L=0.1U	W=0.24U
+ AD=0.0816P	AS=0.0528P	PD=1.16U	PS=0.68U
+ simW=2.4e-07 fw=2.4e-07
MavI11/avD1_3	GND#149	GND#101	avI11/avC13#5	GND#119
+ nmos1v	L=0.1U	W=0.12U
+ AD=0.0408P	AS=0.0696P	PD=0.68U	PS=1.16U
+ simW=1.2e-07 fw=1.2e-07
MavI11/avD1_4	avI11/avC13#8	Q6#8	GND#149	GND#119	nmos1v
+ L=0.1U	W=0.12U
+ AD=0.0696P	AS=0.0408P	PD=1.16U	PS=0.68U
+ simW=1.2e-07 fw=1.2e-07
MavI11/avD1_5	GND#148	avI11/avC11#8	Q6#3	GND#119	nmos1v
+ L=0.1U	W=0.12U
+ AD=0.0408P	AS=0.0696P	PD=0.68U	PS=1.16U
+ simW=1.2e-07 fw=1.2e-07
MavI11/avD1_6	Q6#11	RST#84	GND#148	GND#119	nmos1v	L=0.1U
+ W=0.12U
+ AD=0.0696P	AS=0.0408P	PD=1.16U	PS=0.68U
+ simW=1.2e-07 fw=1.2e-07
MavI11/avD1_7	avI11/avC10	avC13#88	Q5#14	GND#119	nmos1v
+ L=0.1U	W=0.24U
+ AD=0.0528P	AS=0.0816P	PD=0.68U	PS=1.16U
+ simW=2.4e-07 fw=2.4e-07
MavI11/avD1_8	avI11/avC12	CLK#94	avI11/avC10	GND#119	nmos1v
+ L=0.1U	W=0.24U
+ AD=0.0816P	AS=0.0528P	PD=1.16U	PS=0.68U
+ simW=2.4e-07 fw=2.4e-07
MavI11/avD1_9	GND#151	RST#78	avI11/avC12#5	GND#119	nmos1v
+ L=0.1U	W=0.12U
+ AD=0.0408P	AS=0.0696P	PD=0.68U	PS=1.16U
+ simW=1.2e-07 fw=1.2e-07
MavI11/avD1_10	avI11/avC12#8	avI11/avC9#6	GND#151	GND#119
+ nmos1v	L=0.1U	W=0.12U
+ AD=0.0696P	AS=0.0408P	PD=1.16U	PS=0.68U
+ simW=1.2e-07 fw=1.2e-07
MavI11/avD1_11	GND#150	avI11/avC10#8	avI11/avC9#3	GND#119
+ nmos1v	L=0.1U	W=0.12U
+ AD=0.0408P	AS=0.0696P	PD=0.68U	PS=1.16U
+ simW=1.2e-07 fw=1.2e-07
MavI11/avD1_12	avI11/avC9#9	GND#93	GND#150	GND#119	nmos1v
+ L=0.1U	W=0.12U
+ AD=0.0468P	AS=0.0408P	PD=0.68U	PS=0.68U
+ simW=1.2e-07 fw=1.2e-07
MavI10/avD1_1	avI10/avC11	CLK#87	avI10/avC9#9	GND#119	nmos1v
+ L=0.1U	W=0.24U
+ AD=0.0528P	AS=0.0468P	PD=0.68U	PS=0.68U
+ simW=2.4e-07 fw=2.4e-07
MavI10/avD1_2	avI10/avC13	avC13#85	avI10/avC11	GND#119
+ nmos1v	L=0.1U	W=0.24U
+ AD=0.0816P	AS=0.0528P	PD=1.16U	PS=0.68U
+ simW=2.4e-07 fw=2.4e-07
MavI10/avD1_3	GND#153	GND#86	avI10/avC13#5	GND#119	nmos1v
+ L=0.1U	W=0.12U
+ AD=0.0408P	AS=0.0696P	PD=0.68U	PS=1.16U
+ simW=1.2e-07 fw=1.2e-07
MavI10/avD1_4	avI10/avC13#8	Q5#8	GND#153	GND#119	nmos1v
+ L=0.1U	W=0.12U
+ AD=0.0696P	AS=0.0408P	PD=1.16U	PS=0.68U
+ simW=1.2e-07 fw=1.2e-07
MavI10/avD1_5	GND#152	avI10/avC11#8	Q5#3	GND#119	nmos1v
+ L=0.1U	W=0.12U
+ AD=0.0408P	AS=0.0696P	PD=0.68U	PS=1.16U
+ simW=1.2e-07 fw=1.2e-07
MavI10/avD1_6	Q5#11	RST#72	GND#152	GND#119	nmos1v	L=0.1U
+ W=0.12U
+ AD=0.0696P	AS=0.0408P	PD=1.16U	PS=0.68U
+ simW=1.2e-07 fw=1.2e-07
MavI10/avD1_7	avI10/avC10	avC13#75	Q4#14	GND#119	nmos1v
+ L=0.1U	W=0.24U
+ AD=0.0528P	AS=0.0816P	PD=0.68U	PS=1.16U
+ simW=2.4e-07 fw=2.4e-07
MavI10/avD1_8	avI10/avC12	CLK#81	avI10/avC10	GND#119	nmos1v
+ L=0.1U	W=0.24U
+ AD=0.0816P	AS=0.0528P	PD=1.16U	PS=0.68U
+ simW=2.4e-07 fw=2.4e-07
MavI10/avD1_9	GND#155	RST#66	avI10/avC12#5	GND#119	nmos1v
+ L=0.1U	W=0.12U
+ AD=0.0408P	AS=0.0696P	PD=0.68U	PS=1.16U
+ simW=1.2e-07 fw=1.2e-07
MavI10/avD1_10	avI10/avC12#8	avI10/avC9#6	GND#155	GND#119
+ nmos1v	L=0.1U	W=0.12U
+ AD=0.0696P	AS=0.0408P	PD=1.16U	PS=0.68U
+ simW=1.2e-07 fw=1.2e-07
MavI10/avD1_11	GND#154	avI10/avC10#8	avI10/avC9#3	GND#119
+ nmos1v	L=0.1U	W=0.12U
+ AD=0.0408P	AS=0.0696P	PD=0.68U	PS=1.16U
+ simW=1.2e-07 fw=1.2e-07
MavI10/avD1_12	avI10/avC9#9	GND#78	GND#154	GND#119	nmos1v
+ L=0.1U	W=0.12U
+ AD=0.0468P	AS=0.0408P	PD=0.68U	PS=0.68U
+ simW=1.2e-07 fw=1.2e-07
MavI9/avD1_1	avI9/avC11	CLK#74	avI9/avC9#9	GND#119	nmos1v
+ L=0.1U	W=0.24U
+ AD=0.0528P	AS=0.0468P	PD=0.68U	PS=0.68U
+ simW=2.4e-07 fw=2.4e-07
MavI9/avD1_2	avI9/avC13	avC13#72	avI9/avC11	GND#119
+ nmos1v	L=0.1U	W=0.24U
+ AD=0.0816P	AS=0.0528P	PD=1.16U	PS=0.68U
+ simW=2.4e-07 fw=2.4e-07
MavI9/avD1_3	GND#157	GND#71	avI9/avC13#5	GND#119	nmos1v
+ L=0.1U	W=0.12U
+ AD=0.0408P	AS=0.0696P	PD=0.68U	PS=1.16U
+ simW=1.2e-07 fw=1.2e-07
MavI9/avD1_4	avI9/avC13#8	Q4#8	GND#157	GND#119	nmos1v
+ L=0.1U	W=0.12U
+ AD=0.0696P	AS=0.0408P	PD=1.16U	PS=0.68U
+ simW=1.2e-07 fw=1.2e-07
MavI9/avD1_5	GND#156	avI9/avC11#8	Q4#3	GND#119	nmos1v
+ L=0.1U	W=0.12U
+ AD=0.0408P	AS=0.0696P	PD=0.68U	PS=1.16U
+ simW=1.2e-07 fw=1.2e-07
MavI9/avD1_6	Q4#11	RST#60	GND#156	GND#119	nmos1v	L=0.1U
+ W=0.12U
+ AD=0.0696P	AS=0.0408P	PD=1.16U	PS=0.68U
+ simW=1.2e-07 fw=1.2e-07
MavI9/avD1_7	avI9/avC10	avC13#62	Q3#14	GND#119	nmos1v
+ L=0.1U	W=0.24U
+ AD=0.0528P	AS=0.0816P	PD=0.68U	PS=1.16U
+ simW=2.4e-07 fw=2.4e-07
MavI9/avD1_8	avI9/avC12	CLK#68	avI9/avC10	GND#119	nmos1v
+ L=0.1U	W=0.24U
+ AD=0.0816P	AS=0.0528P	PD=1.16U	PS=0.68U
+ simW=2.4e-07 fw=2.4e-07
MavI9/avD1_9	GND#159	RST#54	avI9/avC12#5	GND#119	nmos1v
+ L=0.1U	W=0.12U
+ AD=0.0408P	AS=0.0696P	PD=0.68U	PS=1.16U
+ simW=1.2e-07 fw=1.2e-07
MavI9/avD1_10	avI9/avC12#8	avI9/avC9#6	GND#159	GND#119
+ nmos1v	L=0.1U	W=0.12U
+ AD=0.0696P	AS=0.0408P	PD=1.16U	PS=0.68U
+ simW=1.2e-07 fw=1.2e-07
MavI9/avD1_11	GND#158	avI9/avC10#8	avI9/avC9#3	GND#119
+ nmos1v	L=0.1U	W=0.12U
+ AD=0.0408P	AS=0.0696P	PD=0.68U	PS=1.16U
+ simW=1.2e-07 fw=1.2e-07
MavI9/avD1_12	avI9/avC9#9	GND#63	GND#158	GND#119	nmos1v
+ L=0.1U	W=0.12U
+ AD=0.0468P	AS=0.0408P	PD=0.68U	PS=0.68U
+ simW=1.2e-07 fw=1.2e-07
MavI8/avD1_1	avI8/avC11	CLK#61	avI8/avC9#9	GND#119	nmos1v
+ L=0.1U	W=0.24U
+ AD=0.0528P	AS=0.0468P	PD=0.68U	PS=0.68U
+ simW=2.4e-07 fw=2.4e-07
MavI8/avD1_2	avI8/avC13	avC13#59	avI8/avC11	GND#119
+ nmos1v	L=0.1U	W=0.24U
+ AD=0.0816P	AS=0.0528P	PD=1.16U	PS=0.68U
+ simW=2.4e-07 fw=2.4e-07
MavI8/avD1_3	GND#161	GND#56	avI8/avC13#5	GND#119	nmos1v
+ L=0.1U	W=0.12U
+ AD=0.0408P	AS=0.0696P	PD=0.68U	PS=1.16U
+ simW=1.2e-07 fw=1.2e-07
MavI8/avD1_4	avI8/avC13#8	Q3#8	GND#161	GND#119	nmos1v
+ L=0.1U	W=0.12U
+ AD=0.0696P	AS=0.0408P	PD=1.16U	PS=0.68U
+ simW=1.2e-07 fw=1.2e-07
MavI8/avD1_5	GND#160	avI8/avC11#8	Q3#3	GND#119	nmos1v
+ L=0.1U	W=0.12U
+ AD=0.0408P	AS=0.0696P	PD=0.68U	PS=1.16U
+ simW=1.2e-07 fw=1.2e-07
MavI8/avD1_6	Q3#11	RST#48	GND#160	GND#119	nmos1v	L=0.1U
+ W=0.12U
+ AD=0.0696P	AS=0.0408P	PD=1.16U	PS=0.68U
+ simW=1.2e-07 fw=1.2e-07
MavI8/avD1_7	avI8/avC10	avC13#49	Q2#14	GND#119	nmos1v
+ L=0.1U	W=0.24U
+ AD=0.0528P	AS=0.0816P	PD=0.68U	PS=1.16U
+ simW=2.4e-07 fw=2.4e-07
MavI8/avD1_8	avI8/avC12	CLK#55	avI8/avC10	GND#119	nmos1v
+ L=0.1U	W=0.24U
+ AD=0.0816P	AS=0.0528P	PD=1.16U	PS=0.68U
+ simW=2.4e-07 fw=2.4e-07
MavI8/avD1_9	GND#163	RST#42	avI8/avC12#5	GND#119	nmos1v
+ L=0.1U	W=0.12U
+ AD=0.0408P	AS=0.0696P	PD=0.68U	PS=1.16U
+ simW=1.2e-07 fw=1.2e-07
MavI8/avD1_10	avI8/avC12#8	avI8/avC9#6	GND#163	GND#119
+ nmos1v	L=0.1U	W=0.12U
+ AD=0.0696P	AS=0.0408P	PD=1.16U	PS=0.68U
+ simW=1.2e-07 fw=1.2e-07
MavI8/avD1_11	GND#162	avI8/avC10#8	avI8/avC9#3	GND#119
+ nmos1v	L=0.1U	W=0.12U
+ AD=0.0408P	AS=0.0696P	PD=0.68U	PS=1.16U
+ simW=1.2e-07 fw=1.2e-07
MavI8/avD1_12	avI8/avC9#9	GND#48	GND#162	GND#119	nmos1v
+ L=0.1U	W=0.12U
+ AD=0.0468P	AS=0.0408P	PD=0.68U	PS=0.68U
+ simW=1.2e-07 fw=1.2e-07
MavI7/avD1_1	avI7/avC11	CLK#48	avI7/avC9#9	GND#119	nmos1v
+ L=0.1U	W=0.24U
+ AD=0.0528P	AS=0.0468P	PD=0.68U	PS=0.68U
+ simW=2.4e-07 fw=2.4e-07
MavI7/avD1_2	avI7/avC13	avC13#46	avI7/avC11	GND#119
+ nmos1v	L=0.1U	W=0.24U
+ AD=0.0816P	AS=0.0528P	PD=1.16U	PS=0.68U
+ simW=2.4e-07 fw=2.4e-07
MavI7/avD1_3	GND#165	GND#41	avI7/avC13#5	GND#119	nmos1v
+ L=0.1U	W=0.12U
+ AD=0.0408P	AS=0.0696P	PD=0.68U	PS=1.16U
+ simW=1.2e-07 fw=1.2e-07
MavI7/avD1_4	avI7/avC13#8	Q2#8	GND#165	GND#119	nmos1v
+ L=0.1U	W=0.12U
+ AD=0.0696P	AS=0.0408P	PD=1.16U	PS=0.68U
+ simW=1.2e-07 fw=1.2e-07
MavI7/avD1_5	GND#164	avI7/avC11#8	Q2#3	GND#119	nmos1v
+ L=0.1U	W=0.12U
+ AD=0.0408P	AS=0.0696P	PD=0.68U	PS=1.16U
+ simW=1.2e-07 fw=1.2e-07
MavI7/avD1_6	Q2#11	RST#36	GND#164	GND#119	nmos1v	L=0.1U
+ W=0.12U
+ AD=0.0696P	AS=0.0408P	PD=1.16U	PS=0.68U
+ simW=1.2e-07 fw=1.2e-07
MavI7/avD1_7	avI7/avC10	avC13#36	Q1#14	GND#119	nmos1v
+ L=0.1U	W=0.24U
+ AD=0.0528P	AS=0.0816P	PD=0.68U	PS=1.16U
+ simW=2.4e-07 fw=2.4e-07
MavI7/avD1_8	avI7/avC12	CLK#42	avI7/avC10	GND#119	nmos1v
+ L=0.1U	W=0.24U
+ AD=0.0816P	AS=0.0528P	PD=1.16U	PS=0.68U
+ simW=2.4e-07 fw=2.4e-07
MavI7/avD1_9	GND#167	RST#30	avI7/avC12#5	GND#119	nmos1v
+ L=0.1U	W=0.12U
+ AD=0.0408P	AS=0.0696P	PD=0.68U	PS=1.16U
+ simW=1.2e-07 fw=1.2e-07
MavI7/avD1_10	avI7/avC12#8	avI7/avC9#6	GND#167	GND#119
+ nmos1v	L=0.1U	W=0.12U
+ AD=0.0696P	AS=0.0408P	PD=1.16U	PS=0.68U
+ simW=1.2e-07 fw=1.2e-07
MavI7/avD1_11	GND#166	avI7/avC10#8	avI7/avC9#3	GND#119
+ nmos1v	L=0.1U	W=0.12U
+ AD=0.0408P	AS=0.0696P	PD=0.68U	PS=1.16U
+ simW=1.2e-07 fw=1.2e-07
MavI7/avD1_12	avI7/avC9#9	GND#33	GND#166	GND#119	nmos1v
+ L=0.1U	W=0.12U
+ AD=0.0468P	AS=0.0408P	PD=0.68U	PS=0.68U
+ simW=1.2e-07 fw=1.2e-07
MavI6/avD1_1	avI6/avC11	CLK#35	avI6/avC9#9	GND#119	nmos1v
+ L=0.1U	W=0.24U
+ AD=0.0528P	AS=0.0468P	PD=0.68U	PS=0.68U
+ simW=2.4e-07 fw=2.4e-07
MavI6/avD1_2	avI6/avC13	avC13#33	avI6/avC11	GND#119
+ nmos1v	L=0.1U	W=0.24U
+ AD=0.0816P	AS=0.0528P	PD=1.16U	PS=0.68U
+ simW=2.4e-07 fw=2.4e-07
MavI6/avD1_3	GND#169	GND#26	avI6/avC13#5	GND#119	nmos1v
+ L=0.1U	W=0.12U
+ AD=0.0408P	AS=0.0696P	PD=0.68U	PS=1.16U
+ simW=1.2e-07 fw=1.2e-07
MavI6/avD1_4	avI6/avC13#8	Q1#8	GND#169	GND#119	nmos1v
+ L=0.1U	W=0.12U
+ AD=0.0696P	AS=0.0408P	PD=1.16U	PS=0.68U
+ simW=1.2e-07 fw=1.2e-07
MavI6/avD1_5	GND#168	avI6/avC11#8	Q1#3	GND#119	nmos1v
+ L=0.1U	W=0.12U
+ AD=0.0408P	AS=0.0696P	PD=0.68U	PS=1.16U
+ simW=1.2e-07 fw=1.2e-07
MavI6/avD1_6	Q1#11	RST#24	GND#168	GND#119	nmos1v	L=0.1U
+ W=0.12U
+ AD=0.0696P	AS=0.0408P	PD=1.16U	PS=0.68U
+ simW=1.2e-07 fw=1.2e-07
MavI6/avD1_7	avI6/avC10	avC13#23	Q0#13	GND#119	nmos1v
+ L=0.1U	W=0.24U
+ AD=0.0528P	AS=0.0816P	PD=0.68U	PS=1.16U
+ simW=2.4e-07 fw=2.4e-07
MavI6/avD1_8	avI6/avC12	CLK#29	avI6/avC10	GND#119	nmos1v
+ L=0.1U	W=0.24U
+ AD=0.0816P	AS=0.0528P	PD=1.16U	PS=0.68U
+ simW=2.4e-07 fw=2.4e-07
MavI6/avD1_9	GND#171	RST#18	avI6/avC12#5	GND#119	nmos1v
+ L=0.1U	W=0.12U
+ AD=0.0408P	AS=0.0696P	PD=0.68U	PS=1.16U
+ simW=1.2e-07 fw=1.2e-07
MavI6/avD1_10	avI6/avC12#8	avI6/avC9#6	GND#171	GND#119
+ nmos1v	L=0.1U	W=0.12U
+ AD=0.0696P	AS=0.0408P	PD=1.16U	PS=0.68U
+ simW=1.2e-07 fw=1.2e-07
MavI6/avD1_11	GND#170	avI6/avC10#8	avI6/avC9#3	GND#119
+ nmos1v	L=0.1U	W=0.12U
+ AD=0.0408P	AS=0.0696P	PD=0.68U	PS=1.16U
+ simW=1.2e-07 fw=1.2e-07
MavI6/avD1_12	avI6/avC9#9	GND#18	GND#170	GND#119	nmos1v
+ L=0.1U	W=0.12U
+ AD=0.0468P	AS=0.0408P	PD=0.68U	PS=0.68U
+ simW=1.2e-07 fw=1.2e-07
MavI5/avD1_1	avI5/avC11	CLK#22	avI5/avC9#9	GND#119	nmos1v
+ L=0.1U	W=0.24U
+ AD=0.0528P	AS=0.0468P	PD=0.68U	PS=0.68U
+ simW=2.4e-07 fw=2.4e-07
MavI5/avD1_2	avI5/avC13	avC13#20	avI5/avC11	GND#119
+ nmos1v	L=0.1U	W=0.24U
+ AD=0.0816P	AS=0.0528P	PD=1.16U	PS=0.68U
+ simW=2.4e-07 fw=2.4e-07
MavI5/avD1_3	GND#173	RST#11	avI5/avC13#5	GND#119	nmos1v
+ L=0.1U	W=0.12U
+ AD=0.0408P	AS=0.0696P	PD=0.68U	PS=1.16U
+ simW=1.2e-07 fw=1.2e-07
MavI5/avD1_4	avI5/avC13#8	Q0#8	GND#173	GND#119	nmos1v
+ L=0.1U	W=0.12U
+ AD=0.0696P	AS=0.0408P	PD=1.16U	PS=0.68U
+ simW=1.2e-07 fw=1.2e-07
MavI5/avD1_5	GND#172	avI5/avC11#8	Q0#3	GND#119	nmos1v
+ L=0.1U	W=0.12U
+ AD=0.0408P	AS=0.0696P	PD=0.68U	PS=1.16U
+ simW=1.2e-07 fw=1.2e-07
MavI5/avD1_6	Q0#11	GND#12	GND#172	GND#119	nmos1v	L=0.1U
+ W=0.12U
+ AD=0.0696P	AS=0.0408P	PD=1.16U	PS=0.68U
+ simW=1.2e-07 fw=1.2e-07
MavI5/avD1_7	avI5/avC10	avC13#10	avC14	GND#119	nmos1v
+ L=0.1U	W=0.24U
+ AD=0.0528P	AS=0.0816P	PD=0.68U	PS=1.16U
+ simW=2.4e-07 fw=2.4e-07
MavI5/avD1_8	avI5/avC12	CLK#16	avI5/avC10	GND#119	nmos1v
+ L=0.1U	W=0.24U
+ AD=0.0816P	AS=0.0528P	PD=1.16U	PS=0.68U
+ simW=2.4e-07 fw=2.4e-07
MavI5/avD1_9	GND#175	GND#6	avI5/avC12#5	GND#119	nmos1v
+ L=0.1U	W=0.12U
+ AD=0.0408P	AS=0.0696P	PD=0.68U	PS=1.16U
+ simW=1.2e-07 fw=1.2e-07
MavI5/avD1_10	avI5/avC12#6	avI5/avC9#6	GND#175	GND#119
+ nmos1v	L=0.1U	W=0.12U
+ AD=0.0696P	AS=0.0408P	PD=1.16U	PS=0.68U
+ simW=1.2e-07 fw=1.2e-07
MavI5/avD1_11	GND#174	avI5/avC10#8	avI5/avC9#3	GND#119
+ nmos1v	L=0.1U	W=0.12U
+ AD=0.0408P	AS=0.0696P	PD=0.68U	PS=1.16U
+ simW=1.2e-07 fw=1.2e-07
MavI5/avD1_12	avI5/avC9#9	RST#6	GND#174	GND#119	nmos1v
+ L=0.1U	W=0.12U
+ AD=0.0468P	AS=0.0408P	PD=0.68U	PS=0.68U
+ simW=1.2e-07 fw=1.2e-07
MavI4/avD1_1	avI4/avC6#3	avC16#12	GND#141	GND#119
+ nmos1v	L=0.1U	W=0.12U
+ AD=0.0696P	AS=0.0696P	PD=1.16U	PS=1.16U
+ simW=1.2e-07 fw=1.2e-07
MavI4/avD1_2	avI4/avC8	avI4/avC6#8	GND#140	GND#119
+ nmos1v	L=0.1U	W=0.24U
+ AD=0.0528P	AS=0.0816P	PD=0.68U	PS=1.16U
+ simW=2.4e-07 fw=2.4e-07
MavI4/avD1_3	avC14#11	avI4/avC7#4	avI4/avC8	GND#119
+ nmos1v	L=0.1U	W=0.24U
+ AD=0.0528P	AS=0.0528P	PD=0.68U	PS=0.68U
+ simW=2.4e-07 fw=2.4e-07
MavI4/avD1_4	avI4/avC9	avC15#11	avC14#11	GND#119
+ nmos1v	L=0.1U	W=0.24U
+ AD=0.0528P	AS=0.0528P	PD=0.68U	PS=0.68U
+ simW=2.4e-07 fw=2.4e-07
MavI4/avD1_5	GND#139	avC16#18	avI4/avC9	GND#119
+ nmos1v	L=0.1U	W=0.24U
+ AD=0.0816P	AS=0.0528P	PD=1.16U	PS=0.68U
+ simW=2.4e-07 fw=2.4e-07
MavI4/avD1_6	avI4/avC7#7	avC15#18	GND#118	GND#119
+ nmos1v	L=0.1U	W=0.12U
+ AD=0.0696P	AS=0.0696P	PD=1.16U	PS=1.16U
+ simW=1.2e-07 fw=1.2e-07
MavI3/avD1_1	avC16	avI3/avC6#5	Q7#14	GND#119	nmos1v	L=0.1U
+ W=0.12U
+ AD=0.0468P	AS=0.1992P	PD=0.68U	PS=2.24U
+ simW=1.2e-07 fw=1.2e-07
MavI3/avD1_2	avI3/avC6#6	Q7#19	avC16	GND#119	nmos1v	L=0.1U
+ W=0.24U
+ AD=0.0468P	AS=0.0468P	PD=0.68U	PS=0.68U
+ simW=2.4e-07 fw=2.4e-07
MavI3/avD1_3	GND#142	Q6#33	avI3/avC6#6	GND#119	nmos1v
+ L=0.1U	W=0.12U
+ AD=0.0696P	AS=0.0468P	PD=1.16U	PS=0.68U
+ simW=1.2e-07 fw=1.2e-07
MavI2/avD1_1	avC15	avI2/avC6#5	Q5#22	GND#119	nmos1v	L=0.1U
+ W=0.12U
+ AD=0.0468P	AS=0.1992P	PD=0.68U	PS=2.24U
+ simW=1.2e-07 fw=1.2e-07
MavI2/avD1_2	avI2/avC6#6	Q5#27	avC15	GND#119	nmos1v	L=0.1U
+ W=0.24U
+ AD=0.0468P	AS=0.0468P	PD=0.68U	PS=0.68U
+ simW=2.4e-07 fw=2.4e-07
MavI2/avD1_3	GND#143	Q0#33	avI2/avC6#6	GND#119	nmos1v
+ L=0.1U	W=0.12U
+ AD=0.0696P	AS=0.0468P	PD=1.16U	PS=0.68U
+ simW=1.2e-07 fw=1.2e-07
MavI1/avD1_1	avC13#3	CLK#8	GND#177	GND#119	nmos1v
+ L=0.1U	W=0.24U
+ AD=0.0528P	AS=0.0816P	PD=0.68U	PS=1.16U
+ simW=2.4e-07 fw=2.4e-07
MavI1/avD1_2	GND#178	CLK#12	avC13#3	GND#119	nmos1v
+ L=0.1U	W=0.24U
+ AD=0.0816P	AS=0.0528P	PD=1.16U	PS=0.68U
+ simW=2.4e-07 fw=2.4e-07
MavI12/avD7_1	avI12/avC11#3	avC13#110	avI12/avC9#7	VDD#2	pmos1v
+ L=0.1U	W=0.48U
+ AD=0.1056P	AS=0.2352P	PD=0.92U	PS=1.46U
+ simW=4.8e-07 fw=4.8e-07
MavI12/avD7_2	avI12/avC13#3	CLK#116	avI12/avC11#3	VDD#2	pmos1v
+ L=0.1U	W=0.48U
+ AD=0.1056P	AS=0.1056P	PD=0.92U	PS=0.92U
+ simW=4.8e-07 fw=4.8e-07
MavI12/avD7_3	avI12/avC16	GND#115	avI12/avC13#3	VDD#2	pmos1v
+ L=0.1U	W=0.48U
+ AD=0.1056P	AS=0.1056P	PD=0.92U	PS=0.92U
+ simW=4.8e-07 fw=4.8e-07
MavI12/avD7_4	VDD#27	Q7#7	avI12/avC16	VDD#2	pmos1v	L=0.1U	W=0.48U
+ AD=0.1632P	AS=0.1056P	PD=1.64U	PS=0.92U
+ simW=4.8e-07 fw=4.8e-07
MavI12/avD7_5	avI12/avC17	avI12/avC11#7	VDD#26	VDD#2	pmos1v	L=0.1U
+ W=0.48U
+ AD=0.1056P	AS=0.1632P	PD=0.92U	PS=1.64U
+ simW=4.8e-07 fw=4.8e-07
MavI12/avD7_6	Q7#9	RST#95	avI12/avC17	VDD#2	pmos1v	L=0.1U	W=0.48U
+ AD=0.1632P	AS=0.1056P	PD=1.64U	PS=0.92U
+ simW=4.8e-07 fw=4.8e-07
MavI12/avD7_7	avI12/avC10#3	CLK#106	Q6#21	VDD#2	pmos1v	L=0.1U
+ W=0.48U
+ AD=0.1056P	AS=0.1632P	PD=0.92U	PS=1.64U
+ simW=4.8e-07 fw=4.8e-07
MavI12/avD7_8	avI12/avC12#3	avC13#105	avI12/avC10#3	VDD#2	pmos1v
+ L=0.1U	W=0.48U
+ AD=0.1056P	AS=0.1056P	PD=0.92U	PS=0.92U
+ simW=4.8e-07 fw=4.8e-07
MavI12/avD7_9	avI12/avC14	RST#88	avI12/avC12#3	VDD#2	pmos1v	L=0.1U
+ W=0.48U
+ AD=0.1056P	AS=0.1056P	PD=0.92U	PS=0.92U
+ simW=4.8e-07 fw=4.8e-07
MavI12/avD7_10	VDD#29	avI12/avC9#5	avI12/avC14	VDD#2	pmos1v	L=0.1U
+ W=0.48U
+ AD=0.1632P	AS=0.1056P	PD=1.64U	PS=0.92U
+ simW=4.8e-07 fw=4.8e-07
MavI12/avD7_11	avI12/avC15	avI12/avC10#7	VDD#28	VDD#2	pmos1v	L=0.1U
+ W=0.48U
+ AD=0.1056P	AS=0.1632P	PD=0.92U	PS=1.64U
+ simW=4.8e-07 fw=4.8e-07
MavI12/avD7_12	avI12/avC9#7	GND#106	avI12/avC15	VDD#2	pmos1v
+ L=0.1U	W=0.48U
+ AD=0.2352P	AS=0.1056P	PD=1.46U	PS=0.92U
+ simW=4.8e-07 fw=4.8e-07
MavI11/avD7_1	avI11/avC11#3	avC13#97	avI11/avC9#7	VDD#2	pmos1v
+ L=0.1U	W=0.48U
+ AD=0.1056P	AS=0.2352P	PD=0.92U	PS=1.46U
+ simW=4.8e-07 fw=4.8e-07
MavI11/avD7_2	avI11/avC13#3	CLK#103	avI11/avC11#3	VDD#2	pmos1v
+ L=0.1U	W=0.48U
+ AD=0.1056P	AS=0.1056P	PD=0.92U	PS=0.92U
+ simW=4.8e-07 fw=4.8e-07
MavI11/avD7_3	avI11/avC16	GND#100	avI11/avC13#3	VDD#2	pmos1v
+ L=0.1U	W=0.48U
+ AD=0.1056P	AS=0.1056P	PD=0.92U	PS=0.92U
+ simW=4.8e-07 fw=4.8e-07
MavI11/avD7_4	VDD#31	Q6#7	avI11/avC16	VDD#2	pmos1v	L=0.1U	W=0.48U
+ AD=0.1632P	AS=0.1056P	PD=1.64U	PS=0.92U
+ simW=4.8e-07 fw=4.8e-07
MavI11/avD7_5	avI11/avC17	avI11/avC11#7	VDD#30	VDD#2	pmos1v	L=0.1U
+ W=0.48U
+ AD=0.1056P	AS=0.1632P	PD=0.92U	PS=1.64U
+ simW=4.8e-07 fw=4.8e-07
MavI11/avD7_6	Q6#9	RST#83	avI11/avC17	VDD#2	pmos1v	L=0.1U	W=0.48U
+ AD=0.1632P	AS=0.1056P	PD=1.64U	PS=0.92U
+ simW=4.8e-07 fw=4.8e-07
MavI11/avD7_7	avI11/avC10#3	CLK#93	Q5#21	VDD#2	pmos1v	L=0.1U	W=0.48U
+ AD=0.1056P	AS=0.1632P	PD=0.92U	PS=1.64U
+ simW=4.8e-07 fw=4.8e-07
MavI11/avD7_8	avI11/avC12#3	avC13#92	avI11/avC10#3	VDD#2	pmos1v
+ L=0.1U	W=0.48U
+ AD=0.1056P	AS=0.1056P	PD=0.92U	PS=0.92U
+ simW=4.8e-07 fw=4.8e-07
MavI11/avD7_9	avI11/avC14	RST#76	avI11/avC12#3	VDD#2	pmos1v	L=0.1U
+ W=0.48U
+ AD=0.1056P	AS=0.1056P	PD=0.92U	PS=0.92U
+ simW=4.8e-07 fw=4.8e-07
MavI11/avD7_10	VDD#33	avI11/avC9#5	avI11/avC14	VDD#2	pmos1v	L=0.1U
+ W=0.48U
+ AD=0.1632P	AS=0.1056P	PD=1.64U	PS=0.92U
+ simW=4.8e-07 fw=4.8e-07
MavI11/avD7_11	avI11/avC15	avI11/avC10#7	VDD#32	VDD#2	pmos1v	L=0.1U
+ W=0.48U
+ AD=0.1056P	AS=0.1632P	PD=0.92U	PS=1.64U
+ simW=4.8e-07 fw=4.8e-07
MavI11/avD7_12	avI11/avC9#7	GND#91	avI11/avC15	VDD#2	pmos1v	L=0.1U
+ W=0.48U
+ AD=0.2352P	AS=0.1056P	PD=1.46U	PS=0.92U
+ simW=4.8e-07 fw=4.8e-07
MavI10/avD7_1	avI10/avC11#3	avC13#84	avI10/avC9#7	VDD#2	pmos1v
+ L=0.1U	W=0.48U
+ AD=0.1056P	AS=0.2352P	PD=0.92U	PS=1.46U
+ simW=4.8e-07 fw=4.8e-07
MavI10/avD7_2	avI10/avC13#3	CLK#90	avI10/avC11#3	VDD#2	pmos1v	L=0.1U
+ W=0.48U
+ AD=0.1056P	AS=0.1056P	PD=0.92U	PS=0.92U
+ simW=4.8e-07 fw=4.8e-07
MavI10/avD7_3	avI10/avC16	GND#85	avI10/avC13#3	VDD#2	pmos1v	L=0.1U
+ W=0.48U
+ AD=0.1056P	AS=0.1056P	PD=0.92U	PS=0.92U
+ simW=4.8e-07 fw=4.8e-07
MavI10/avD7_4	VDD#35	Q5#7	avI10/avC16	VDD#2	pmos1v	L=0.1U	W=0.48U
+ AD=0.1632P	AS=0.1056P	PD=1.64U	PS=0.92U
+ simW=4.8e-07 fw=4.8e-07
MavI10/avD7_5	avI10/avC17	avI10/avC11#7	VDD#34	VDD#2	pmos1v	L=0.1U
+ W=0.48U
+ AD=0.1056P	AS=0.1632P	PD=0.92U	PS=1.64U
+ simW=4.8e-07 fw=4.8e-07
MavI10/avD7_6	Q5#9	RST#71	avI10/avC17	VDD#2	pmos1v	L=0.1U	W=0.48U
+ AD=0.1632P	AS=0.1056P	PD=1.64U	PS=0.92U
+ simW=4.8e-07 fw=4.8e-07
MavI10/avD7_7	avI10/avC10#3	CLK#80	Q4#21	VDD#2	pmos1v	L=0.1U	W=0.48U
+ AD=0.1056P	AS=0.1632P	PD=0.92U	PS=1.64U
+ simW=4.8e-07 fw=4.8e-07
MavI10/avD7_8	avI10/avC12#3	avC13#79	avI10/avC10#3	VDD#2	pmos1v
+ L=0.1U	W=0.48U
+ AD=0.1056P	AS=0.1056P	PD=0.92U	PS=0.92U
+ simW=4.8e-07 fw=4.8e-07
MavI10/avD7_9	avI10/avC14	RST#64	avI10/avC12#3	VDD#2	pmos1v	L=0.1U
+ W=0.48U
+ AD=0.1056P	AS=0.1056P	PD=0.92U	PS=0.92U
+ simW=4.8e-07 fw=4.8e-07
MavI10/avD7_10	VDD#37	avI10/avC9#5	avI10/avC14	VDD#2	pmos1v	L=0.1U
+ W=0.48U
+ AD=0.1632P	AS=0.1056P	PD=1.64U	PS=0.92U
+ simW=4.8e-07 fw=4.8e-07
MavI10/avD7_11	avI10/avC15	avI10/avC10#7	VDD#36	VDD#2	pmos1v	L=0.1U
+ W=0.48U
+ AD=0.1056P	AS=0.1632P	PD=0.92U	PS=1.64U
+ simW=4.8e-07 fw=4.8e-07
MavI10/avD7_12	avI10/avC9#7	GND#76	avI10/avC15	VDD#2	pmos1v	L=0.1U
+ W=0.48U
+ AD=0.2352P	AS=0.1056P	PD=1.46U	PS=0.92U
+ simW=4.8e-07 fw=4.8e-07
MavI9/avD7_1	avI9/avC11#3	avC13#71	avI9/avC9#7	VDD#2	pmos1v
+ L=0.1U	W=0.48U
+ AD=0.1056P	AS=0.2352P	PD=0.92U	PS=1.46U
+ simW=4.8e-07 fw=4.8e-07
MavI9/avD7_2	avI9/avC13#3	CLK#77	avI9/avC11#3	VDD#2	pmos1v	L=0.1U
+ W=0.48U
+ AD=0.1056P	AS=0.1056P	PD=0.92U	PS=0.92U
+ simW=4.8e-07 fw=4.8e-07
MavI9/avD7_3	avI9/avC16	GND#70	avI9/avC13#3	VDD#2	pmos1v	L=0.1U
+ W=0.48U
+ AD=0.1056P	AS=0.1056P	PD=0.92U	PS=0.92U
+ simW=4.8e-07 fw=4.8e-07
MavI9/avD7_4	VDD#39	Q4#7	avI9/avC16	VDD#2	pmos1v	L=0.1U	W=0.48U
+ AD=0.1632P	AS=0.1056P	PD=1.64U	PS=0.92U
+ simW=4.8e-07 fw=4.8e-07
MavI9/avD7_5	avI9/avC17	avI9/avC11#7	VDD#38	VDD#2	pmos1v	L=0.1U
+ W=0.48U
+ AD=0.1056P	AS=0.1632P	PD=0.92U	PS=1.64U
+ simW=4.8e-07 fw=4.8e-07
MavI9/avD7_6	Q4#9	RST#59	avI9/avC17	VDD#2	pmos1v	L=0.1U	W=0.48U
+ AD=0.1632P	AS=0.1056P	PD=1.64U	PS=0.92U
+ simW=4.8e-07 fw=4.8e-07
MavI9/avD7_7	avI9/avC10#3	CLK#67	Q3#21	VDD#2	pmos1v	L=0.1U	W=0.48U
+ AD=0.1056P	AS=0.1632P	PD=0.92U	PS=1.64U
+ simW=4.8e-07 fw=4.8e-07
MavI9/avD7_8	avI9/avC12#3	avC13#66	avI9/avC10#3	VDD#2	pmos1v
+ L=0.1U	W=0.48U
+ AD=0.1056P	AS=0.1056P	PD=0.92U	PS=0.92U
+ simW=4.8e-07 fw=4.8e-07
MavI9/avD7_9	avI9/avC14	RST#52	avI9/avC12#3	VDD#2	pmos1v	L=0.1U
+ W=0.48U
+ AD=0.1056P	AS=0.1056P	PD=0.92U	PS=0.92U
+ simW=4.8e-07 fw=4.8e-07
MavI9/avD7_10	VDD#41	avI9/avC9#5	avI9/avC14	VDD#2	pmos1v	L=0.1U
+ W=0.48U
+ AD=0.1632P	AS=0.1056P	PD=1.64U	PS=0.92U
+ simW=4.8e-07 fw=4.8e-07
MavI9/avD7_11	avI9/avC15	avI9/avC10#7	VDD#40	VDD#2	pmos1v	L=0.1U
+ W=0.48U
+ AD=0.1056P	AS=0.1632P	PD=0.92U	PS=1.64U
+ simW=4.8e-07 fw=4.8e-07
MavI9/avD7_12	avI9/avC9#7	GND#61	avI9/avC15	VDD#2	pmos1v	L=0.1U
+ W=0.48U
+ AD=0.2352P	AS=0.1056P	PD=1.46U	PS=0.92U
+ simW=4.8e-07 fw=4.8e-07
MavI8/avD7_1	avI8/avC11#3	avC13#58	avI8/avC9#7	VDD#2	pmos1v
+ L=0.1U	W=0.48U
+ AD=0.1056P	AS=0.2352P	PD=0.92U	PS=1.46U
+ simW=4.8e-07 fw=4.8e-07
MavI8/avD7_2	avI8/avC13#3	CLK#64	avI8/avC11#3	VDD#2	pmos1v	L=0.1U
+ W=0.48U
+ AD=0.1056P	AS=0.1056P	PD=0.92U	PS=0.92U
+ simW=4.8e-07 fw=4.8e-07
MavI8/avD7_3	avI8/avC16	GND#55	avI8/avC13#3	VDD#2	pmos1v	L=0.1U
+ W=0.48U
+ AD=0.1056P	AS=0.1056P	PD=0.92U	PS=0.92U
+ simW=4.8e-07 fw=4.8e-07
MavI8/avD7_4	VDD#43	Q3#7	avI8/avC16	VDD#2	pmos1v	L=0.1U	W=0.48U
+ AD=0.1632P	AS=0.1056P	PD=1.64U	PS=0.92U
+ simW=4.8e-07 fw=4.8e-07
MavI8/avD7_5	avI8/avC17	avI8/avC11#7	VDD#42	VDD#2	pmos1v	L=0.1U
+ W=0.48U
+ AD=0.1056P	AS=0.1632P	PD=0.92U	PS=1.64U
+ simW=4.8e-07 fw=4.8e-07
MavI8/avD7_6	Q3#9	RST#47	avI8/avC17	VDD#2	pmos1v	L=0.1U	W=0.48U
+ AD=0.1632P	AS=0.1056P	PD=1.64U	PS=0.92U
+ simW=4.8e-07 fw=4.8e-07
MavI8/avD7_7	avI8/avC10#3	CLK#54	Q2#21	VDD#2	pmos1v	L=0.1U	W=0.48U
+ AD=0.1056P	AS=0.1632P	PD=0.92U	PS=1.64U
+ simW=4.8e-07 fw=4.8e-07
MavI8/avD7_8	avI8/avC12#3	avC13#53	avI8/avC10#3	VDD#2	pmos1v
+ L=0.1U	W=0.48U
+ AD=0.1056P	AS=0.1056P	PD=0.92U	PS=0.92U
+ simW=4.8e-07 fw=4.8e-07
MavI8/avD7_9	avI8/avC14	RST#40	avI8/avC12#3	VDD#2	pmos1v	L=0.1U
+ W=0.48U
+ AD=0.1056P	AS=0.1056P	PD=0.92U	PS=0.92U
+ simW=4.8e-07 fw=4.8e-07
MavI8/avD7_10	VDD#45	avI8/avC9#5	avI8/avC14	VDD#2	pmos1v	L=0.1U
+ W=0.48U
+ AD=0.1632P	AS=0.1056P	PD=1.64U	PS=0.92U
+ simW=4.8e-07 fw=4.8e-07
MavI8/avD7_11	avI8/avC15	avI8/avC10#7	VDD#44	VDD#2	pmos1v	L=0.1U
+ W=0.48U
+ AD=0.1056P	AS=0.1632P	PD=0.92U	PS=1.64U
+ simW=4.8e-07 fw=4.8e-07
MavI8/avD7_12	avI8/avC9#7	GND#46	avI8/avC15	VDD#2	pmos1v	L=0.1U
+ W=0.48U
+ AD=0.2352P	AS=0.1056P	PD=1.46U	PS=0.92U
+ simW=4.8e-07 fw=4.8e-07
MavI7/avD7_1	avI7/avC11#3	avC13#45	avI7/avC9#7	VDD#2	pmos1v
+ L=0.1U	W=0.48U
+ AD=0.1056P	AS=0.2352P	PD=0.92U	PS=1.46U
+ simW=4.8e-07 fw=4.8e-07
MavI7/avD7_2	avI7/avC13#3	CLK#51	avI7/avC11#3	VDD#2	pmos1v	L=0.1U
+ W=0.48U
+ AD=0.1056P	AS=0.1056P	PD=0.92U	PS=0.92U
+ simW=4.8e-07 fw=4.8e-07
MavI7/avD7_3	avI7/avC16	GND#40	avI7/avC13#3	VDD#2	pmos1v	L=0.1U
+ W=0.48U
+ AD=0.1056P	AS=0.1056P	PD=0.92U	PS=0.92U
+ simW=4.8e-07 fw=4.8e-07
MavI7/avD7_4	VDD#47	Q2#7	avI7/avC16	VDD#2	pmos1v	L=0.1U	W=0.48U
+ AD=0.1632P	AS=0.1056P	PD=1.64U	PS=0.92U
+ simW=4.8e-07 fw=4.8e-07
MavI7/avD7_5	avI7/avC17	avI7/avC11#7	VDD#46	VDD#2	pmos1v	L=0.1U
+ W=0.48U
+ AD=0.1056P	AS=0.1632P	PD=0.92U	PS=1.64U
+ simW=4.8e-07 fw=4.8e-07
MavI7/avD7_6	Q2#9	RST#35	avI7/avC17	VDD#2	pmos1v	L=0.1U	W=0.48U
+ AD=0.1632P	AS=0.1056P	PD=1.64U	PS=0.92U
+ simW=4.8e-07 fw=4.8e-07
MavI7/avD7_7	avI7/avC10#3	CLK#41	Q1#21	VDD#2	pmos1v	L=0.1U	W=0.48U
+ AD=0.1056P	AS=0.1632P	PD=0.92U	PS=1.64U
+ simW=4.8e-07 fw=4.8e-07
MavI7/avD7_8	avI7/avC12#3	avC13#40	avI7/avC10#3	VDD#2	pmos1v
+ L=0.1U	W=0.48U
+ AD=0.1056P	AS=0.1056P	PD=0.92U	PS=0.92U
+ simW=4.8e-07 fw=4.8e-07
MavI7/avD7_9	avI7/avC14	RST#28	avI7/avC12#3	VDD#2	pmos1v	L=0.1U
+ W=0.48U
+ AD=0.1056P	AS=0.1056P	PD=0.92U	PS=0.92U
+ simW=4.8e-07 fw=4.8e-07
MavI7/avD7_10	VDD#49	avI7/avC9#5	avI7/avC14	VDD#2	pmos1v	L=0.1U
+ W=0.48U
+ AD=0.1632P	AS=0.1056P	PD=1.64U	PS=0.92U
+ simW=4.8e-07 fw=4.8e-07
MavI7/avD7_11	avI7/avC15	avI7/avC10#7	VDD#48	VDD#2	pmos1v	L=0.1U
+ W=0.48U
+ AD=0.1056P	AS=0.1632P	PD=0.92U	PS=1.64U
+ simW=4.8e-07 fw=4.8e-07
MavI7/avD7_12	avI7/avC9#7	GND#31	avI7/avC15	VDD#2	pmos1v	L=0.1U
+ W=0.48U
+ AD=0.2352P	AS=0.1056P	PD=1.46U	PS=0.92U
+ simW=4.8e-07 fw=4.8e-07
MavI6/avD7_1	avI6/avC11#3	avC13#32	avI6/avC9#7	VDD#2	pmos1v
+ L=0.1U	W=0.48U
+ AD=0.1056P	AS=0.2352P	PD=0.92U	PS=1.46U
+ simW=4.8e-07 fw=4.8e-07
MavI6/avD7_2	avI6/avC13#3	CLK#38	avI6/avC11#3	VDD#2	pmos1v	L=0.1U
+ W=0.48U
+ AD=0.1056P	AS=0.1056P	PD=0.92U	PS=0.92U
+ simW=4.8e-07 fw=4.8e-07
MavI6/avD7_3	avI6/avC16	GND#25	avI6/avC13#3	VDD#2	pmos1v	L=0.1U
+ W=0.48U
+ AD=0.1056P	AS=0.1056P	PD=0.92U	PS=0.92U
+ simW=4.8e-07 fw=4.8e-07
MavI6/avD7_4	VDD#51	Q1#7	avI6/avC16	VDD#2	pmos1v	L=0.1U	W=0.48U
+ AD=0.1632P	AS=0.1056P	PD=1.64U	PS=0.92U
+ simW=4.8e-07 fw=4.8e-07
MavI6/avD7_5	avI6/avC17	avI6/avC11#7	VDD#50	VDD#2	pmos1v	L=0.1U
+ W=0.48U
+ AD=0.1056P	AS=0.1632P	PD=0.92U	PS=1.64U
+ simW=4.8e-07 fw=4.8e-07
MavI6/avD7_6	Q1#9	RST#23	avI6/avC17	VDD#2	pmos1v	L=0.1U	W=0.48U
+ AD=0.1632P	AS=0.1056P	PD=1.64U	PS=0.92U
+ simW=4.8e-07 fw=4.8e-07
MavI6/avD7_7	avI6/avC10#3	CLK#28	Q0#21	VDD#2	pmos1v	L=0.1U	W=0.48U
+ AD=0.1056P	AS=0.1632P	PD=0.92U	PS=1.64U
+ simW=4.8e-07 fw=4.8e-07
MavI6/avD7_8	avI6/avC12#3	avC13#27	avI6/avC10#3	VDD#2	pmos1v
+ L=0.1U	W=0.48U
+ AD=0.1056P	AS=0.1056P	PD=0.92U	PS=0.92U
+ simW=4.8e-07 fw=4.8e-07
MavI6/avD7_9	avI6/avC14	RST#16	avI6/avC12#3	VDD#2	pmos1v	L=0.1U
+ W=0.48U
+ AD=0.1056P	AS=0.1056P	PD=0.92U	PS=0.92U
+ simW=4.8e-07 fw=4.8e-07
MavI6/avD7_10	VDD#53	avI6/avC9#5	avI6/avC14	VDD#2	pmos1v	L=0.1U
+ W=0.48U
+ AD=0.1632P	AS=0.1056P	PD=1.64U	PS=0.92U
+ simW=4.8e-07 fw=4.8e-07
MavI6/avD7_11	avI6/avC15	avI6/avC10#7	VDD#52	VDD#2	pmos1v	L=0.1U
+ W=0.48U
+ AD=0.1056P	AS=0.1632P	PD=0.92U	PS=1.64U
+ simW=4.8e-07 fw=4.8e-07
MavI6/avD7_12	avI6/avC9#7	GND#16	avI6/avC15	VDD#2	pmos1v	L=0.1U
+ W=0.48U
+ AD=0.2352P	AS=0.1056P	PD=1.46U	PS=0.92U
+ simW=4.8e-07 fw=4.8e-07
MavI5/avD7_1	avI5/avC11#3	avC13#19	avI5/avC9#7	VDD#2	pmos1v
+ L=0.1U	W=0.48U
+ AD=0.1056P	AS=0.2352P	PD=0.92U	PS=1.46U
+ simW=4.8e-07 fw=4.8e-07
MavI5/avD7_2	avI5/avC13#3	CLK#25	avI5/avC11#3	VDD#2	pmos1v	L=0.1U
+ W=0.48U
+ AD=0.1056P	AS=0.1056P	PD=0.92U	PS=0.92U
+ simW=4.8e-07 fw=4.8e-07
MavI5/avD7_3	avI5/avC16	RST#10	avI5/avC13#3	VDD#2	pmos1v	L=0.1U
+ W=0.48U
+ AD=0.1056P	AS=0.1056P	PD=0.92U	PS=0.92U
+ simW=4.8e-07 fw=4.8e-07
MavI5/avD7_4	VDD#55	Q0#7	avI5/avC16	VDD#2	pmos1v	L=0.1U	W=0.48U
+ AD=0.1632P	AS=0.1056P	PD=1.64U	PS=0.92U
+ simW=4.8e-07 fw=4.8e-07
MavI5/avD7_5	avI5/avC17	avI5/avC11#7	VDD#54	VDD#2	pmos1v	L=0.1U
+ W=0.48U
+ AD=0.1056P	AS=0.1632P	PD=0.92U	PS=1.64U
+ simW=4.8e-07 fw=4.8e-07
MavI5/avD7_6	Q0#9	GND#11	avI5/avC17	VDD#2	pmos1v	L=0.1U	W=0.48U
+ AD=0.1632P	AS=0.1056P	PD=1.64U	PS=0.92U
+ simW=4.8e-07 fw=4.8e-07
MavI5/avD7_7	avI5/avC10#3	CLK#15	avC14#8	VDD#2	pmos1v	L=0.1U
+ W=0.48U
+ AD=0.1056P	AS=0.1632P	PD=0.92U	PS=1.64U
+ simW=4.8e-07 fw=4.8e-07
MavI5/avD7_8	avI5/avC12#3	avC13#14	avI5/avC10#3	VDD#2	pmos1v
+ L=0.1U	W=0.48U
+ AD=0.1056P	AS=0.1056P	PD=0.92U	PS=0.92U
+ simW=4.8e-07 fw=4.8e-07
MavI5/avD7_9	avI5/avC14	GND#4	avI5/avC12#3	VDD#2	pmos1v	L=0.1U
+ W=0.48U
+ AD=0.1056P	AS=0.1056P	PD=0.92U	PS=0.92U
+ simW=4.8e-07 fw=4.8e-07
MavI5/avD7_10	VDD#57	avI5/avC9#5	avI5/avC14	VDD#2	pmos1v	L=0.1U
+ W=0.48U
+ AD=0.1632P	AS=0.1056P	PD=1.64U	PS=0.92U
+ simW=4.8e-07 fw=4.8e-07
MavI5/avD7_11	avI5/avC15	avI5/avC10#7	VDD#56	VDD#2	pmos1v	L=0.1U
+ W=0.48U
+ AD=0.1056P	AS=0.1632P	PD=0.92U	PS=1.64U
+ simW=4.8e-07 fw=4.8e-07
MavI5/avD7_12	avI5/avC9#7	RST#4	avI5/avC15	VDD#2	pmos1v	L=0.1U
+ W=0.48U
+ AD=0.2352P	AS=0.1056P	PD=1.46U	PS=0.92U
+ simW=4.8e-07 fw=4.8e-07
MavI4/avD7_1	VDD#23	avC16#11	avI4/avC6	VDD#2	pmos1v	L=0.1U
+ W=0.24U
+ AD=0.0816P	AS=0.0816P	PD=1.16U	PS=1.16U
+ simW=2.4e-07 fw=2.4e-07
MavI4/avD7_2	avC14#9	avI4/avC6#7	avI4/avC10#2	VDD#2	pmos1v
+ L=0.1U	W=0.48U
+ AD=0.1056P	AS=0.1632P	PD=0.92U	PS=1.64U
+ simW=4.8e-07 fw=4.8e-07
MavI4/avD7_3	avI4/avC10#4	avI4/avC7#3	avC14#9	VDD#2	pmos1v
+ L=0.1U	W=0.48U
+ AD=0.1056P	AS=0.1056P	PD=0.92U	PS=0.92U
+ simW=4.8e-07 fw=4.8e-07
MavI4/avD7_4	VDD#22	avC15#10	avI4/avC10#4	VDD#2	pmos1v	L=0.1U
+ W=0.48U
+ AD=0.1056P	AS=0.1056P	PD=0.92U	PS=0.92U
+ simW=4.8e-07 fw=4.8e-07
MavI4/avD7_5	avI4/avC10#6	avC16#17	VDD#22	VDD#2	pmos1v	L=0.1U
+ W=0.48U
+ AD=0.1632P	AS=0.1056P	PD=1.64U	PS=0.92U
+ simW=4.8e-07 fw=4.8e-07
MavI4/avD7_6	VDD#1	avC15#16	avI4/avC7#5	VDD#2	pmos1v	L=0.1U
+ W=0.24U
+ AD=0.0816P	AS=0.0816P	PD=1.16U	PS=1.16U
+ simW=2.4e-07 fw=2.4e-07
MavI3/avD7_1	VDD#24	Q6#25	avI3/avC6	VDD#2	pmos1v	L=0.1U	W=0.24U
+ AD=0.0816P	AS=0.0816P	PD=1.16U	PS=1.16U
+ simW=2.4e-07 fw=2.4e-07
MavI3/avD7_2	avC16#3	Q7#18	Q6#29	VDD#2	pmos1v	L=0.1U	W=0.48U
+ AD=0.0936P	AS=0.1632P	PD=0.92U	PS=1.64U
+ simW=4.8e-07 fw=4.8e-07
MavI3/avD7_3	Q7#20	Q6#32	avC16#3	VDD#2	pmos1v	L=0.1U	W=0.24U
+ AD=0.0816P	AS=0.0936P	PD=1.16U	PS=0.92U
+ simW=2.4e-07 fw=2.4e-07
MavI2/avD7_1	VDD#25	Q0#25	avI2/avC6	VDD#2	pmos1v	L=0.1U	W=0.24U
+ AD=0.0816P	AS=0.0816P	PD=1.16U	PS=1.16U
+ simW=2.4e-07 fw=2.4e-07
MavI2/avD7_2	avC15#3	Q5#26	Q0#27	VDD#2	pmos1v	L=0.1U	W=0.48U
+ AD=0.0936P	AS=0.1632P	PD=0.92U	PS=1.64U
+ simW=4.8e-07 fw=4.8e-07
MavI2/avD7_3	Q5#28	Q0#32	avC15#3	VDD#2	pmos1v	L=0.1U	W=0.24U
+ AD=0.0816P	AS=0.0936P	PD=1.16U	PS=0.92U
+ simW=2.4e-07 fw=2.4e-07
MavI1/avD7_1	avC13	CLK#6	VDD#60	VDD#2	pmos1v	L=0.1U	W=0.48U
+ AD=0.1056P	AS=0.1632P	PD=0.92U	PS=1.64U
+ simW=4.8e-07 fw=4.8e-07
MavI1/avD7_2	VDD#58	CLK#11	avC13	VDD#2	pmos1v	L=0.1U	W=0.48U
+ AD=0.1632P	AS=0.1056P	PD=1.64U	PS=0.92U
+ simW=4.8e-07 fw=4.8e-07
*
*
*       RESISTOR AND CAP/DIODE CARDS
*
Rj1	CLK#6	CLK#7	   36.5435	$poly
Rj2	CLK#7	CLK#8	   48.5435	$poly
Rj3	CLK#1	CLK#7	   10.0000	$poly
Rj4	CLK#11	CLK#9	   36.5435	$poly
Rj5	CLK#9	CLK#12	   48.5435	$poly
Rj6	avC13#10	avC13#8	   48.5435	$poly
Rj7	CLK#15	CLK#13	   36.5435	$poly
Rj8	CLK#13	CLK#16	   48.5435	$poly
Rj9	avC13#14	avC13#11	   46.5435	$poly
Rj10	GND#4	GND#5	   36.5435	$poly
Rj11	GND#5	GND#6	   54.5435	$poly
Rj12	GND#1	GND#5	   10.0000	$poly
Rj13	avI5/avC9#5	avI5/avC9	   36.5435	$poly
Rj14	avI5/avC9	avI5/avC9#6	   54.5435	$poly
Rj15	avI5/avC10#7	avI5/avC10#5	   36.5435	$poly
Rj16	avI5/avC10#5	avI5/avC10#8	   54.5435	$poly
Rj17	RST#4	RST#5	   36.5435	$poly
Rj18	RST#5	RST#6	   54.5435	$poly
Rj19	RST#1	RST#5	   10.0000	$poly
Rj20	CLK#22	CLK#19	   58.5435	$poly
Rj21	avC13#19	avC13#17	   36.5435	$poly
Rj22	avC13#17	avC13#20	   48.5435	$poly
Rj23	CLK#25	CLK#23	   36.5435	$poly
Rj24	RST#10	RST#7	   36.5435	$poly
Rj25	RST#7	RST#11	   54.5435	$poly
Rj26	Q0#7	Q0#1	   36.5435	$poly
Rj27	Q0#1	Q0#8	   54.5435	$poly
Rj28	avI5/avC11#7	avI5/avC11#5	   36.5435	$poly
Rj29	avI5/avC11#5	avI5/avC11#8	   54.5435	$poly
Rj30	GND#11	GND#7	   36.5435	$poly
Rj31	GND#7	GND#12	   54.5435	$poly
Rj32	avC13#23	avC13#21	   48.5435	$poly
Rj33	CLK#28	CLK#26	   36.5435	$poly
Rj34	CLK#26	CLK#29	   48.5435	$poly
Rj35	avC13#27	avC13#24	   46.5435	$poly
Rj36	RST#16	RST#17	   36.5435	$poly
Rj37	RST#17	RST#18	   54.5435	$poly
Rj38	RST#13	RST#17	   10.0000	$poly
Rj39	avI6/avC9#5	avI6/avC9	   36.5435	$poly
Rj40	avI6/avC9	avI6/avC9#6	   54.5435	$poly
Rj41	avI6/avC10#7	avI6/avC10#5	   36.5435	$poly
Rj42	avI6/avC10#5	avI6/avC10#8	   54.5435	$poly
Rj43	GND#16	GND#17	   36.5435	$poly
Rj44	GND#17	GND#18	   54.5435	$poly
Rj45	GND#13	GND#17	   10.0000	$poly
Rj46	CLK#35	CLK#32	   58.5435	$poly
Rj47	avC13#32	avC13#30	   36.5435	$poly
Rj48	avC13#30	avC13#33	   48.5435	$poly
Rj49	CLK#38	CLK#36	   36.5435	$poly
Rj50	GND#25	GND#23	   36.5435	$poly
Rj51	GND#23	GND#26	   54.5435	$poly
Rj52	Q1#7	Q1#1	   36.5435	$poly
Rj53	Q1#1	Q1#8	   54.5435	$poly
Rj54	avI6/avC11#7	avI6/avC11#5	   36.5435	$poly
Rj55	avI6/avC11#5	avI6/avC11#8	   54.5435	$poly
Rj56	RST#23	RST#21	   36.5435	$poly
Rj57	RST#21	RST#24	   54.5435	$poly
Rj58	avC13#36	avC13#34	   48.5435	$poly
Rj59	CLK#41	CLK#39	   36.5435	$poly
Rj60	CLK#39	CLK#42	   48.5435	$poly
Rj61	avC13#40	avC13#37	   46.5435	$poly
Rj62	RST#28	RST#29	   36.5435	$poly
Rj63	RST#29	RST#30	   54.5435	$poly
Rj64	RST#25	RST#29	   10.0000	$poly
Rj65	avI7/avC9#5	avI7/avC9	   36.5435	$poly
Rj66	avI7/avC9	avI7/avC9#6	   54.5435	$poly
Rj67	avI7/avC10#7	avI7/avC10#5	   36.5435	$poly
Rj68	avI7/avC10#5	avI7/avC10#8	   54.5435	$poly
Rj69	GND#31	GND#32	   36.5435	$poly
Rj70	GND#32	GND#33	   54.5435	$poly
Rj71	GND#28	GND#32	   10.0000	$poly
Rj72	CLK#48	CLK#45	   58.5435	$poly
Rj73	avC13#45	avC13#43	   36.5435	$poly
Rj74	avC13#43	avC13#46	   48.5435	$poly
Rj75	CLK#51	CLK#49	   36.5435	$poly
Rj76	GND#40	GND#38	   36.5435	$poly
Rj77	GND#38	GND#41	   54.5435	$poly
Rj78	Q2#7	Q2#1	   36.5435	$poly
Rj79	Q2#1	Q2#8	   54.5435	$poly
Rj80	avI7/avC11#7	avI7/avC11#5	   36.5435	$poly
Rj81	avI7/avC11#5	avI7/avC11#8	   54.5435	$poly
Rj82	RST#35	RST#33	   36.5435	$poly
Rj83	RST#33	RST#36	   54.5435	$poly
Rj84	avC13#49	avC13#47	   48.5435	$poly
Rj85	CLK#54	CLK#52	   36.5435	$poly
Rj86	CLK#52	CLK#55	   48.5435	$poly
Rj87	avC13#53	avC13#50	   46.5435	$poly
Rj88	RST#40	RST#41	   36.5435	$poly
Rj89	RST#41	RST#42	   54.5435	$poly
Rj90	RST#37	RST#41	   10.0000	$poly
Rj91	avI8/avC9#5	avI8/avC9	   36.5435	$poly
Rj92	avI8/avC9	avI8/avC9#6	   54.5435	$poly
Rj93	avI8/avC10#7	avI8/avC10#5	   36.5435	$poly
Rj94	avI8/avC10#5	avI8/avC10#8	   54.5435	$poly
Rj95	GND#46	GND#47	   36.5435	$poly
Rj96	GND#47	GND#48	   54.5435	$poly
Rj97	GND#43	GND#47	   10.0000	$poly
Rj98	CLK#61	CLK#58	   58.5435	$poly
Rj99	avC13#58	avC13#56	   36.5435	$poly
Rj100	avC13#56	avC13#59	   48.5435	$poly
Rj101	CLK#64	CLK#62	   36.5435	$poly
Rj102	GND#55	GND#53	   36.5435	$poly
Rj103	GND#53	GND#56	   54.5435	$poly
Rj104	Q3#7	Q3#1	   36.5435	$poly
Rj105	Q3#1	Q3#8	   54.5435	$poly
Rj106	avI8/avC11#7	avI8/avC11#5	   36.5435	$poly
Rj107	avI8/avC11#5	avI8/avC11#8	   54.5435	$poly
Rj108	RST#47	RST#45	   36.5435	$poly
Rj109	RST#45	RST#48	   54.5435	$poly
Rj110	avC13#62	avC13#60	   48.5435	$poly
Rj111	CLK#67	CLK#65	   36.5435	$poly
Rj112	CLK#65	CLK#68	   48.5435	$poly
Rj113	avC13#66	avC13#63	   46.5435	$poly
Rj114	RST#52	RST#53	   36.5435	$poly
Rj115	RST#53	RST#54	   54.5435	$poly
Rj116	RST#49	RST#53	   10.0000	$poly
Rj117	avI9/avC9#5	avI9/avC9	   36.5435	$poly
Rj118	avI9/avC9	avI9/avC9#6	   54.5435	$poly
Rj119	avI9/avC10#7	avI9/avC10#5	   36.5435	$poly
Rj120	avI9/avC10#5	avI9/avC10#8	   54.5435	$poly
Rj121	GND#61	GND#62	   36.5435	$poly
Rj122	GND#62	GND#63	   54.5435	$poly
Rj123	GND#58	GND#62	   10.0000	$poly
Rj124	CLK#74	CLK#71	   58.5435	$poly
Rj125	avC13#71	avC13#69	   36.5435	$poly
Rj126	avC13#69	avC13#72	   48.5435	$poly
Rj127	CLK#77	CLK#75	   36.5435	$poly
Rj128	GND#70	GND#68	   36.5435	$poly
Rj129	GND#68	GND#71	   54.5435	$poly
Rj130	Q4#7	Q4#1	   36.5435	$poly
Rj131	Q4#1	Q4#8	   54.5435	$poly
Rj132	avI9/avC11#7	avI9/avC11#5	   36.5435	$poly
Rj133	avI9/avC11#5	avI9/avC11#8	   54.5435	$poly
Rj134	RST#59	RST#57	   36.5435	$poly
Rj135	RST#57	RST#60	   54.5435	$poly
Rj136	avC13#75	avC13#73	   48.5435	$poly
Rj137	CLK#80	CLK#78	   36.5435	$poly
Rj138	CLK#78	CLK#81	   48.5435	$poly
Rj139	avC13#79	avC13#76	   46.5435	$poly
Rj140	RST#64	RST#65	   36.5435	$poly
Rj141	RST#65	RST#66	   54.5435	$poly
Rj142	RST#61	RST#65	   10.0000	$poly
Rj143	avI10/avC9#5	avI10/avC9	   36.5435	$poly
Rj144	avI10/avC9	avI10/avC9#6	   54.5435	$poly
Rj145	avI10/avC10#7	avI10/avC10#5	   36.5435	$poly
Rj146	avI10/avC10#5	avI10/avC10#8	   54.5435	$poly
Rj147	GND#76	GND#77	   36.5435	$poly
Rj148	GND#77	GND#78	   54.5435	$poly
Rj149	GND#73	GND#77	   10.0000	$poly
Rj150	CLK#87	CLK#84	   58.5435	$poly
Rj151	avC13#84	avC13#82	   36.5435	$poly
Rj152	avC13#82	avC13#85	   48.5435	$poly
Rj153	CLK#90	CLK#88	   36.5435	$poly
Rj154	GND#85	GND#83	   36.5435	$poly
Rj155	GND#83	GND#86	   54.5435	$poly
Rj156	Q5#7	Q5#1	   36.5435	$poly
Rj157	Q5#1	Q5#8	   54.5435	$poly
Rj158	avI10/avC11#7	avI10/avC11#5	   36.5435	$poly
Rj159	avI10/avC11#5	avI10/avC11#8	   54.5435	$poly
Rj160	RST#71	RST#69	   36.5435	$poly
Rj161	RST#69	RST#72	   54.5435	$poly
Rj162	avC13#88	avC13#86	   48.5435	$poly
Rj163	CLK#93	CLK#91	   36.5435	$poly
Rj164	CLK#91	CLK#94	   48.5435	$poly
Rj165	avC13#92	avC13#89	   46.5435	$poly
Rj166	RST#76	RST#77	   36.5435	$poly
Rj167	RST#77	RST#78	   54.5435	$poly
Rj168	RST#73	RST#77	   10.0000	$poly
Rj169	avI11/avC9#5	avI11/avC9	   36.5435	$poly
Rj170	avI11/avC9	avI11/avC9#6	   54.5435	$poly
Rj171	avI11/avC10#7	avI11/avC10#5	   36.5435	$poly
Rj172	avI11/avC10#5	avI11/avC10#8	   54.5435	$poly
Rj173	GND#91	GND#92	   36.5435	$poly
Rj174	GND#92	GND#93	   54.5435	$poly
Rj175	GND#88	GND#92	   10.0000	$poly
Rj176	CLK#100	CLK#97	   58.5435	$poly
Rj177	avC13#97	avC13#95	   36.5435	$poly
Rj178	avC13#95	avC13#98	   48.5435	$poly
Rj179	CLK#103	CLK#101	   36.5435	$poly
Rj180	GND#100	GND#98	   36.5435	$poly
Rj181	GND#98	GND#101	   54.5435	$poly
Rj182	Q6#7	Q6#1	   36.5435	$poly
Rj183	Q6#1	Q6#8	   54.5435	$poly
Rj184	avI11/avC11#7	avI11/avC11#5	   36.5435	$poly
Rj185	avI11/avC11#5	avI11/avC11#8	   54.5435	$poly
Rj186	RST#83	RST#81	   36.5435	$poly
Rj187	RST#81	RST#84	   54.5435	$poly
Rj188	avC13#101	avC13#99	   48.5435	$poly
Rj189	CLK#106	CLK#104	   36.5435	$poly
Rj190	CLK#104	CLK#107	   48.5435	$poly
Rj191	avC13#105	avC13#102	   46.5435	$poly
Rj192	RST#88	RST#89	   36.5435	$poly
Rj193	RST#89	RST#90	   54.5435	$poly
Rj194	RST#85	RST#89	   10.0000	$poly
Rj195	avI12/avC9#5	avI12/avC9	   36.5435	$poly
Rj196	avI12/avC9	avI12/avC9#6	   54.5435	$poly
Rj197	avI12/avC10#7	avI12/avC10#5	   36.5435	$poly
Rj198	avI12/avC10#5	avI12/avC10#8	   54.5435	$poly
Rj199	GND#106	GND#107	   36.5435	$poly
Rj200	GND#107	GND#108	   54.5435	$poly
Rj201	GND#103	GND#107	   10.0000	$poly
Rj202	CLK#113	CLK#110	   58.5435	$poly
Rj203	avC13#110	avC13#108	   36.5435	$poly
Rj204	avC13#108	avC13#111	   48.5435	$poly
Rj205	CLK#116	CLK#114	   36.5435	$poly
Rj206	GND#115	GND#113	   36.5435	$poly
Rj207	GND#113	GND#116	   54.5435	$poly
Rj208	Q7#7	Q7#1	   36.5435	$poly
Rj209	Q7#1	Q7#8	   54.5435	$poly
Rj210	avI12/avC11#7	avI12/avC11#5	   36.5435	$poly
Rj211	avI12/avC11#5	avI12/avC11#8	   54.5435	$poly
Rj212	RST#95	RST#93	   36.5435	$poly
Rj213	RST#93	RST#96	   54.5435	$poly
Rj214	Q0#25	Q0#22	   58.5435	$poly
Rj215	avI2/avC6#5	avI2/avC6#3	   54.5435	$poly
Rj216	Q5#26	Q5#24	   36.5435	$poly
Rj217	Q5#24	Q5#27	   48.5435	$poly
Rj218	Q0#32	Q0#30	   48.5435	$poly
Rj219	Q0#30	Q0#33	   54.5435	$poly
Rj220	Q6#25	Q6#22	   58.5435	$poly
Rj221	avI3/avC6#5	avI3/avC6#3	   54.5435	$poly
Rj222	Q7#18	Q7#16	   36.5435	$poly
Rj223	Q7#16	Q7#19	   48.5435	$poly
Rj224	Q6#32	Q6#30	   48.5435	$poly
Rj225	Q6#30	Q6#33	   54.5435	$poly
Rj226	avC16#11	avC16#8	   48.5435	$poly
Rj227	avC16#8	avC16#12	   54.5435	$poly
Rj228	avI4/avC6#7	avI4/avC6#5	   36.5435	$poly
Rj229	avI4/avC6#5	avI4/avC6#8	   48.5435	$poly
Rj230	avI4/avC7#3	avI4/avC7	   36.5435	$poly
Rj231	avI4/avC7	avI4/avC7#4	   48.5435	$poly
Rj232	avC15#10	avC15#8	   36.5435	$poly
Rj233	avC15#8	avC15#11	   48.5435	$poly
Rj234	avC16#17	avC16#15	   36.5435	$poly
Rj235	avC16#15	avC16#18	   48.5435	$poly
Rj236	avC15#16	avC15#17	   48.5435	$poly
Rj237	avC15#17	avC15#18	   54.5435	$poly
Rj238	avC15#12	avC15#17	   10.0000	$poly
Ri2	CLK#1	CLK#3	    1.8373	$mt1
Ri3	avC13	avC13#2	   15.6453	$mt1
Ri4	avC13#2	avC13#4	8.000E-02	$mt1
Ri6	avC13#3	avC13#4	   15.0000	$mt1
Ri7	CLK#9	CLK#10	   11.8373	$mt1
Ri9	avC14#2	avC14#4	    2.2533	$mt1
Ri10	avC14	avC14#2	   15.0000	$mt1
Ri11	avC13#8	avC13#9	   11.5813	$mt1
Ri12	avC14#8	avC14#7	   15.1280	$mt1
Ri13	avI5/avC10	avI5/avC10#2	   16.7893	$mt1
Ri14	CLK#13	CLK#14	   11.7360	$mt1
Ri15	avI5/avC10#3	avI5/avC10#4	   16.7360	$mt1
Ri16	avI5/avC12	avI5/avC12#2	   16.4800	$mt1
Ri18	avC13#11	avC13#13	    1.5813	$mt1
Ri19	avI5/avC12#3	avI5/avC12#4	   15.6453	$mt1
Ri20	avI5/avC12#4	avI5/avC12#5	   15.0800	$mt1
Ri22	GND#1	GND#3	    1.8373	$mt1
Ri23	avI5/avC9	avI5/avC9#2	   11.5280	$mt1
Ri24	avI5/avC12#6	avI5/avC12#7	   16.4800	$mt1
Ri25	avI5/avC9#3	avI5/avC9#4	   16.6347	$mt1
Ri26	avI5/avC10#5	avI5/avC10#6	   11.4267	$mt1
Ri28	RST#1	RST#3	    1.8907	$mt1
Ri29	avI5/avC9#7	avI5/avC9#8	   15.4907	$mt1
Ri30	avI5/avC9#8	avI5/avC9#9	   15.2347	$mt1
Ri32	CLK#19	CLK#21	    1.7360	$mt1
Ri33	avI5/avC11	avI5/avC11#2	   16.7893	$mt1
Ri34	avC13#17	avC13#18	   11.5813	$mt1
Ri35	avI5/avC11#3	avI5/avC11#4	   16.7360	$mt1
Ri36	avI5/avC13	avI5/avC13#2	   16.4800	$mt1
Ri37	CLK#23	CLK#24	   11.7360	$mt1
Ri38	avI5/avC13#3	avI5/avC13#4	   15.6453	$mt1
Ri39	avI5/avC13#4	avI5/avC13#5	   15.0800	$mt1
Ri40	RST#7	RST#8	   11.8907	$mt1
Ri41	Q0#1	Q0#2	   11.5280	$mt1
Ri42	avI5/avC13#8	avI5/avC13#6	   15.0800	$mt1
Ri44	Q0#4	Q0#6	    1.6347	$mt1
Ri45	Q0#3	Q0#4	   15.0000	$mt1
Ri46	avI5/avC11#5	avI5/avC11#6	   11.4267	$mt1
Ri47	GND#7	GND#8	   11.8373	$mt1
Ri48	Q0#9	Q0#10	   15.4907	$mt1
Ri49	Q0#10	Q0#11	   15.2347	$mt1
Ri51	Q0#14	Q0#16	    2.2533	$mt1
Ri52	Q0#13	Q0#14	   15.0000	$mt1
Ri53	avC13#21	avC13#22	   11.5813	$mt1
Ri54	Q0#21	Q0#20	   15.1280	$mt1
Ri55	avI6/avC10	avI6/avC10#2	   16.7893	$mt1
Ri56	CLK#26	CLK#27	   11.7360	$mt1
Ri57	avI6/avC10#3	avI6/avC10#4	   16.7360	$mt1
Ri58	avI6/avC12	avI6/avC12#2	   16.4800	$mt1
Ri60	avC13#24	avC13#26	    1.5813	$mt1
Ri61	avI6/avC12#3	avI6/avC12#4	   15.6453	$mt1
Ri62	avI6/avC12#4	avI6/avC12#5	   15.0800	$mt1
Ri64	RST#13	RST#15	    1.8373	$mt1
Ri65	avI6/avC9	avI6/avC9#2	   11.5280	$mt1
Ri66	avI6/avC12#8	avI6/avC12#6	   15.0800	$mt1
Ri67	avI6/avC9#3	avI6/avC9#4	   16.6347	$mt1
Ri68	avI6/avC10#5	avI6/avC10#6	   11.4267	$mt1
Ri70	GND#13	GND#15	    1.8907	$mt1
Ri71	avI6/avC9#7	avI6/avC9#8	   15.4907	$mt1
Ri72	avI6/avC9#8	avI6/avC9#9	   15.2347	$mt1
Ri74	CLK#32	CLK#34	    1.7360	$mt1
Ri75	avI6/avC11	avI6/avC11#2	   16.7893	$mt1
Ri76	avC13#30	avC13#31	   11.5813	$mt1
Ri77	avI6/avC11#3	avI6/avC11#4	   16.7360	$mt1
Ri78	avI6/avC13	avI6/avC13#2	   16.4800	$mt1
Ri79	CLK#36	CLK#37	   11.7360	$mt1
Ri80	avI6/avC13#3	avI6/avC13#4	   15.6453	$mt1
Ri81	avI6/avC13#4	avI6/avC13#5	   15.0800	$mt1
Ri82	GND#23	GND#24	   11.8907	$mt1
Ri83	Q1#1	Q1#2	   11.5280	$mt1
Ri84	avI6/avC13#8	avI6/avC13#6	   15.0800	$mt1
Ri86	Q1#4	Q1#6	    1.6347	$mt1
Ri87	Q1#3	Q1#4	   15.0000	$mt1
Ri88	avI6/avC11#5	avI6/avC11#6	   11.4267	$mt1
Ri89	RST#21	RST#22	   11.8373	$mt1
Ri90	Q1#9	Q1#10	   15.4907	$mt1
Ri91	Q1#10	Q1#11	   15.2347	$mt1
Ri93	Q1#15	Q1#17	    2.2533	$mt1
Ri94	Q1#14	Q1#15	   15.0000	$mt1
Ri95	avC13#34	avC13#35	   11.5813	$mt1
Ri96	Q1#21	Q1#20	   15.1280	$mt1
Ri97	avI7/avC10	avI7/avC10#2	   16.7893	$mt1
Ri98	CLK#39	CLK#40	   11.7360	$mt1
Ri99	avI7/avC10#3	avI7/avC10#4	   16.7360	$mt1
Ri100	avI7/avC12	avI7/avC12#2	   16.4800	$mt1
Ri102	avC13#37	avC13#39	    1.5813	$mt1
Ri103	avI7/avC12#3	avI7/avC12#4	   15.6453	$mt1
Ri104	avI7/avC12#4	avI7/avC12#5	   15.0800	$mt1
Ri106	RST#25	RST#27	    1.8373	$mt1
Ri107	avI7/avC9	avI7/avC9#2	   11.5280	$mt1
Ri108	avI7/avC12#8	avI7/avC12#6	   15.0800	$mt1
Ri109	avI7/avC9#3	avI7/avC9#4	   16.6347	$mt1
Ri110	avI7/avC10#5	avI7/avC10#6	   11.4267	$mt1
Ri112	GND#28	GND#30	    1.8907	$mt1
Ri113	avI7/avC9#7	avI7/avC9#8	   15.4907	$mt1
Ri114	avI7/avC9#8	avI7/avC9#9	   15.2347	$mt1
Ri116	CLK#45	CLK#47	    1.7360	$mt1
Ri117	avI7/avC11	avI7/avC11#2	   16.7893	$mt1
Ri118	avC13#43	avC13#44	   11.5813	$mt1
Ri119	avI7/avC11#3	avI7/avC11#4	   16.7360	$mt1
Ri120	avI7/avC13	avI7/avC13#2	   16.4800	$mt1
Ri121	CLK#49	CLK#50	   11.7360	$mt1
Ri122	avI7/avC13#3	avI7/avC13#4	   15.6453	$mt1
Ri123	avI7/avC13#4	avI7/avC13#5	   15.0800	$mt1
Ri124	GND#38	GND#39	   11.8907	$mt1
Ri125	Q2#1	Q2#2	   11.5280	$mt1
Ri126	avI7/avC13#8	avI7/avC13#6	   15.0800	$mt1
Ri128	Q2#4	Q2#6	    1.6347	$mt1
Ri129	Q2#3	Q2#4	   15.0000	$mt1
Ri130	avI7/avC11#5	avI7/avC11#6	   11.4267	$mt1
Ri131	RST#33	RST#34	   11.8373	$mt1
Ri132	Q2#9	Q2#10	   15.4907	$mt1
Ri133	Q2#10	Q2#11	   15.2347	$mt1
Ri135	Q2#15	Q2#17	    2.2533	$mt1
Ri136	Q2#14	Q2#15	   15.0000	$mt1
Ri137	avC13#47	avC13#48	   11.5813	$mt1
Ri138	Q2#21	Q2#20	   15.1280	$mt1
Ri139	avI8/avC10	avI8/avC10#2	   16.7893	$mt1
Ri140	CLK#52	CLK#53	   11.7360	$mt1
Ri141	avI8/avC10#3	avI8/avC10#4	   16.7360	$mt1
Ri142	avI8/avC12	avI8/avC12#2	   16.4800	$mt1
Ri144	avC13#50	avC13#52	    1.5813	$mt1
Ri145	avI8/avC12#3	avI8/avC12#4	   15.6453	$mt1
Ri146	avI8/avC12#4	avI8/avC12#5	   15.0800	$mt1
Ri148	RST#37	RST#39	    1.8373	$mt1
Ri149	avI8/avC9	avI8/avC9#2	   11.5280	$mt1
Ri150	avI8/avC12#8	avI8/avC12#6	   15.0800	$mt1
Ri151	avI8/avC9#3	avI8/avC9#4	   16.6347	$mt1
Ri152	avI8/avC10#5	avI8/avC10#6	   11.4267	$mt1
Ri154	GND#43	GND#45	    1.8907	$mt1
Ri155	avI8/avC9#7	avI8/avC9#8	   15.4907	$mt1
Ri156	avI8/avC9#8	avI8/avC9#9	   15.2347	$mt1
Ri158	CLK#58	CLK#60	    1.7360	$mt1
Ri159	avI8/avC11	avI8/avC11#2	   16.7893	$mt1
Ri160	avC13#56	avC13#57	   11.5813	$mt1
Ri161	avI8/avC11#3	avI8/avC11#4	   16.7360	$mt1
Ri162	avI8/avC13	avI8/avC13#2	   16.4800	$mt1
Ri163	CLK#62	CLK#63	   11.7360	$mt1
Ri164	avI8/avC13#3	avI8/avC13#4	   15.6453	$mt1
Ri165	avI8/avC13#4	avI8/avC13#5	   15.0800	$mt1
Ri166	GND#53	GND#54	   11.8907	$mt1
Ri167	Q3#1	Q3#2	   11.5280	$mt1
Ri168	avI8/avC13#8	avI8/avC13#6	   15.0800	$mt1
Ri170	Q3#4	Q3#6	    1.6347	$mt1
Ri171	Q3#3	Q3#4	   15.0000	$mt1
Ri172	avI8/avC11#5	avI8/avC11#6	   11.4267	$mt1
Ri173	RST#45	RST#46	   11.8373	$mt1
Ri174	Q3#9	Q3#10	   15.4907	$mt1
Ri175	Q3#10	Q3#11	   15.2347	$mt1
Ri177	Q3#15	Q3#17	    2.2533	$mt1
Ri178	Q3#14	Q3#15	   15.0000	$mt1
Ri179	avC13#60	avC13#61	   11.5813	$mt1
Ri180	Q3#21	Q3#20	   15.1280	$mt1
Ri181	avI9/avC10	avI9/avC10#2	   16.7893	$mt1
Ri182	CLK#65	CLK#66	   11.7360	$mt1
Ri183	avI9/avC10#3	avI9/avC10#4	   16.7360	$mt1
Ri184	avI9/avC12	avI9/avC12#2	   16.4800	$mt1
Ri186	avC13#63	avC13#65	    1.5813	$mt1
Ri187	avI9/avC12#3	avI9/avC12#4	   15.6453	$mt1
Ri188	avI9/avC12#4	avI9/avC12#5	   15.0800	$mt1
Ri190	RST#49	RST#51	    1.8373	$mt1
Ri191	avI9/avC9	avI9/avC9#2	   11.5280	$mt1
Ri192	avI9/avC12#8	avI9/avC12#6	   15.0800	$mt1
Ri193	avI9/avC9#3	avI9/avC9#4	   16.6347	$mt1
Ri194	avI9/avC10#5	avI9/avC10#6	   11.4267	$mt1
Ri196	GND#58	GND#60	    1.8907	$mt1
Ri197	avI9/avC9#7	avI9/avC9#8	   15.4907	$mt1
Ri198	avI9/avC9#8	avI9/avC9#9	   15.2347	$mt1
Ri200	CLK#71	CLK#73	    1.7360	$mt1
Ri201	avI9/avC11	avI9/avC11#2	   16.7893	$mt1
Ri202	avC13#69	avC13#70	   11.5813	$mt1
Ri203	avI9/avC11#3	avI9/avC11#4	   16.7360	$mt1
Ri204	avI9/avC13	avI9/avC13#2	   16.4800	$mt1
Ri205	CLK#75	CLK#76	   11.7360	$mt1
Ri206	avI9/avC13#3	avI9/avC13#4	   15.6453	$mt1
Ri207	avI9/avC13#4	avI9/avC13#5	   15.0800	$mt1
Ri208	GND#68	GND#69	   11.8907	$mt1
Ri209	Q4#1	Q4#2	   11.5280	$mt1
Ri210	avI9/avC13#8	avI9/avC13#6	   15.0800	$mt1
Ri212	Q4#4	Q4#6	    1.6347	$mt1
Ri213	Q4#3	Q4#4	   15.0000	$mt1
Ri214	avI9/avC11#5	avI9/avC11#6	   11.4267	$mt1
Ri215	RST#57	RST#58	   11.8373	$mt1
Ri216	Q4#9	Q4#10	   15.4907	$mt1
Ri217	Q4#10	Q4#11	   15.2347	$mt1
Ri219	Q4#15	Q4#17	    2.2533	$mt1
Ri220	Q4#14	Q4#15	   15.0000	$mt1
Ri221	avC13#73	avC13#74	   11.5813	$mt1
Ri222	Q4#21	Q4#20	   15.1280	$mt1
Ri223	avI10/avC10	avI10/avC10#2	   16.7893	$mt1
Ri224	CLK#78	CLK#79	   11.7360	$mt1
Ri225	avI10/avC10#3	avI10/avC10#4	   16.7360	$mt1
Ri226	avI10/avC12	avI10/avC12#2	   16.4800	$mt1
Ri228	avC13#76	avC13#78	    1.5813	$mt1
Ri229	avI10/avC12#3	avI10/avC12#4	   15.6453	$mt1
Ri230	avI10/avC12#4	avI10/avC12#5	   15.0800	$mt1
Ri232	RST#61	RST#63	    1.8373	$mt1
Ri233	avI10/avC9	avI10/avC9#2	   11.5280	$mt1
Ri234	avI10/avC12#8	avI10/avC12#6	   15.0800	$mt1
Ri235	avI10/avC9#3	avI10/avC9#4	   16.6347	$mt1
Ri236	avI10/avC10#5	avI10/avC10#6	   11.4267	$mt1
Ri238	GND#73	GND#75	    1.8907	$mt1
Ri239	avI10/avC9#7	avI10/avC9#8	   15.4907	$mt1
Ri240	avI10/avC9#8	avI10/avC9#9	   15.2347	$mt1
Ri242	CLK#84	CLK#86	    1.7360	$mt1
Ri243	avI10/avC11	avI10/avC11#2	   16.7893	$mt1
Ri244	avC13#82	avC13#83	   11.5813	$mt1
Ri245	avI10/avC11#3	avI10/avC11#4	   16.7360	$mt1
Ri246	avI10/avC13	avI10/avC13#2	   16.4800	$mt1
Ri247	CLK#88	CLK#89	   11.7360	$mt1
Ri248	avI10/avC13#3	avI10/avC13#4	   15.6453	$mt1
Ri249	avI10/avC13#4	avI10/avC13#5	   15.0800	$mt1
Ri250	GND#83	GND#84	   11.8907	$mt1
Ri251	Q5#1	Q5#2	   11.5280	$mt1
Ri252	avI10/avC13#8	avI10/avC13#6	   15.0800	$mt1
Ri254	Q5#4	Q5#6	    1.6347	$mt1
Ri255	Q5#3	Q5#4	   15.0000	$mt1
Ri256	avI10/avC11#5	avI10/avC11#6	   11.4267	$mt1
Ri257	RST#69	RST#70	   11.8373	$mt1
Ri258	Q5#9	Q5#10	   15.4907	$mt1
Ri259	Q5#10	Q5#11	   15.2347	$mt1
Ri261	Q5#15	Q5#17	    2.2533	$mt1
Ri262	Q5#14	Q5#15	   15.0000	$mt1
Ri263	avC13#86	avC13#87	   11.5813	$mt1
Ri264	Q5#21	Q5#20	   15.1280	$mt1
Ri265	avI11/avC10	avI11/avC10#2	   16.7893	$mt1
Ri266	CLK#91	CLK#92	   11.7360	$mt1
Ri267	avI11/avC10#3	avI11/avC10#4	   16.7360	$mt1
Ri268	avI11/avC12	avI11/avC12#2	   16.4800	$mt1
Ri270	avC13#89	avC13#91	    1.5813	$mt1
Ri271	avI11/avC12#3	avI11/avC12#4	   15.6453	$mt1
Ri272	avI11/avC12#4	avI11/avC12#5	   15.0800	$mt1
Ri274	RST#73	RST#75	    1.8373	$mt1
Ri275	avI11/avC9	avI11/avC9#2	   11.5280	$mt1
Ri276	avI11/avC12#8	avI11/avC12#6	   15.0800	$mt1
Ri277	avI11/avC9#3	avI11/avC9#4	   16.6347	$mt1
Ri278	avI11/avC10#5	avI11/avC10#6	   11.4267	$mt1
Ri280	GND#88	GND#90	    1.8907	$mt1
Ri281	avI11/avC9#7	avI11/avC9#8	   15.4907	$mt1
Ri282	avI11/avC9#8	avI11/avC9#9	   15.2347	$mt1
Ri284	CLK#97	CLK#99	    1.7360	$mt1
Ri285	avI11/avC11	avI11/avC11#2	   16.7893	$mt1
Ri286	avC13#95	avC13#96	   11.5813	$mt1
Ri287	avI11/avC11#3	avI11/avC11#4	   16.7360	$mt1
Ri288	avI11/avC13	avI11/avC13#2	   16.4800	$mt1
Ri289	CLK#101	CLK#102	   11.7360	$mt1
Ri290	avI11/avC13#3	avI11/avC13#4	   15.6453	$mt1
Ri291	avI11/avC13#4	avI11/avC13#5	   15.0800	$mt1
Ri292	GND#98	GND#99	   11.8907	$mt1
Ri293	Q6#1	Q6#2	   11.5280	$mt1
Ri294	avI11/avC13#8	avI11/avC13#6	   15.0800	$mt1
Ri296	Q6#4	Q6#6	    1.6347	$mt1
Ri297	Q6#3	Q6#4	   15.0000	$mt1
Ri298	avI11/avC11#5	avI11/avC11#6	   11.4267	$mt1
Ri299	RST#81	RST#82	   11.8373	$mt1
Ri300	Q6#9	Q6#10	   15.4907	$mt1
Ri301	Q6#10	Q6#11	   15.2347	$mt1
Ri303	Q6#14	Q6#16	    2.2533	$mt1
Ri304	Q6#13	Q6#14	   15.0000	$mt1
Ri305	avC13#99	avC13#100	   11.5813	$mt1
Ri306	Q6#21	Q6#20	   15.1280	$mt1
Ri307	avI12/avC10	avI12/avC10#2	   16.7893	$mt1
Ri308	CLK#104	CLK#105	   11.7360	$mt1
Ri309	avI12/avC10#3	avI12/avC10#4	   16.7360	$mt1
Ri310	avI12/avC12	avI12/avC12#2	   16.4800	$mt1
Ri312	avC13#102	avC13#104	    1.5813	$mt1
Ri313	avI12/avC12#3	avI12/avC12#4	   15.6453	$mt1
Ri314	avI12/avC12#4	avI12/avC12#5	   15.0800	$mt1
Ri316	RST#85	RST#87	    1.8373	$mt1
Ri317	avI12/avC9	avI12/avC9#2	   11.5280	$mt1
Ri318	avI12/avC12#8	avI12/avC12#6	   15.0800	$mt1
Ri319	avI12/avC9#3	avI12/avC9#4	   16.6347	$mt1
Ri320	avI12/avC10#5	avI12/avC10#6	   11.4267	$mt1
Ri322	GND#103	GND#105	    1.8907	$mt1
Ri323	avI12/avC9#7	avI12/avC9#8	   15.4907	$mt1
Ri324	avI12/avC9#8	avI12/avC9#9	   15.2347	$mt1
Ri326	CLK#110	CLK#112	    1.7360	$mt1
Ri327	avI12/avC11	avI12/avC11#2	   16.7893	$mt1
Ri328	avC13#108	avC13#109	   11.5813	$mt1
Ri329	avI12/avC11#3	avI12/avC11#4	   16.7360	$mt1
Ri330	avI12/avC13	avI12/avC13#2	   16.4800	$mt1
Ri331	CLK#114	CLK#115	   11.7360	$mt1
Ri332	avI12/avC13#3	avI12/avC13#4	   15.6453	$mt1
Ri333	avI12/avC13#4	avI12/avC13#5	   15.0800	$mt1
Ri334	GND#113	GND#114	   11.8907	$mt1
Ri335	Q7#1	Q7#2	   11.5280	$mt1
Ri336	avI12/avC13#8	avI12/avC13#6	   15.0800	$mt1
Ri338	Q7#4	Q7#6	    1.6347	$mt1
Ri339	Q7#3	Q7#4	   15.0000	$mt1
Ri340	avI12/avC11#5	avI12/avC11#6	   11.4267	$mt1
Ri341	RST#93	RST#94	   11.8373	$mt1
Ri342	Q7#9	Q7#10	   15.4907	$mt1
Ri343	Q7#10	Q7#11	   15.2347	$mt1
Ri344	avI2/avC6	avI2/avC6#2	   17.0453	$mt1
Ri345	Q0#22	Q0#23	6.133E-02	$mt1
Ri346	Q0#23	Q0#24	    1.6747	$mt1
Ri347	Q5#22	Q5#23	   16.6347	$mt1
Ri348	avI2/avC6#3	avI2/avC6#4	   11.6827	$mt1
Ri349	Q0#26	Q0#27	   16.4267	$mt1
Ri350	avC15	avC15#2	   16.7893	$mt1
Ri351	Q5#24	Q5#25	   11.5280	$mt1
Ri352	avC15#3	avC15#4	   15.3013	$mt1
Ri353	avC15#4	avC15#5	    1.4347	$mt1
Ri354	avI2/avC6#6	avI2/avC6#7	   16.4800	$mt1
Ri355	Q0#30	Q0#31	   11.7360	$mt1
Ri356	Q5#28	Q5#29	   15.3600	$mt1
Ri357	Q5#29	Q5#30	    1.5307	$mt1
Ri358	avI3/avC6	avI3/avC6#2	   17.0453	$mt1
Ri359	Q6#22	Q6#23	6.133E-02	$mt1
Ri360	Q6#23	Q6#24	    1.6747	$mt1
Ri361	Q7#14	Q7#15	   16.6347	$mt1
Ri362	avI3/avC6#3	avI3/avC6#4	   11.6827	$mt1
Ri363	Q6#28	Q6#29	   16.4267	$mt1
Ri364	avC16	avC16#2	   16.7893	$mt1
Ri365	Q7#16	Q7#17	   11.5280	$mt1
Ri366	avC16#3	avC16#4	   15.3013	$mt1
Ri367	avC16#4	avC16#5	    1.4347	$mt1
Ri368	avI3/avC6#6	avI3/avC6#7	   16.4800	$mt1
Ri369	Q6#30	Q6#31	   11.7360	$mt1
Ri370	Q7#20	Q7#21	   15.3600	$mt1
Ri371	Q7#21	Q7#22	    1.5307	$mt1
Ri372	avI4/avC6	avI4/avC6#2	   16.8907	$mt1
Ri373	avC16#8	avC16#9	   10.0267	$mt1
Ri374	avC16#9	avC16#10	3.467E-02	$mt1
Ri375	avI4/avC6#3	avI4/avC6#4	   16.6347	$mt1
Ri376	avI4/avC10	avI4/avC10#2	   16.4267	$mt1
Ri377	avI4/avC6#5	avI4/avC6#6	   11.5280	$mt1
Ri378	avC14#9	avC14#10	   17.0453	$mt1
Ri379	avI4/avC7	avI4/avC7#2	   11.5280	$mt1
Ri380	avI4/avC10#3	avI4/avC10#4	   16.4267	$mt1
Ri381	avC14#11	avC14#12	   15.0453	$mt1
Ri382	avC14#12	avC14#13	    1.4347	$mt1
Ri383	avC15#8	avC15#9	   11.5813	$mt1
Ri384	avC16#15	avC16#16	   11.4267	$mt1
Ri385	avI4/avC10#5	avI4/avC10#6	   15.0267	$mt1
Ri386	avI4/avC7#5	avI4/avC7#6	   16.8907	$mt1
Ri387	avC15#12	avC15#13	6.133E-02	$mt1
Ri388	avC15#13	avC15#14	    1.5200	$mt1
Ri389	avI4/avC7#7	avI4/avC7#8	   16.6347	$mt1
Ri390	VDD#1	VDD	   15.4290	$mt1
Ri391	VDD#3	VDD	   10.7280	$mt1
Ri392	VDD#4	VDD	    9.7200	$mt1
Ri393	VDD#5	VDD	    9.0000	$mt1
Ri394	VDD#6	VDD	    8.0280	$mt1
Ri395	VDD#7	VDD	    6.8400	$mt1
Ri396	VDD#8	VDD	    5.5800	$mt1
Ri397	VDD#9	VDD	    4.3920	$mt1
Ri398	VDD#10	VDD	    3.1320	$mt1
Ri399	VDD#11	VDD	    1.9440	$mt1
Ri400	VDD#12	VDD	    0.6840	$mt1
Ri401	VDD	VDD#13	    0.5040	$mt1
Ri402	VDD	VDD#14	    1.7640	$mt1
Ri403	VDD	VDD#15	    2.9520	$mt1
Ri404	VDD	VDD#16	    4.2120	$mt1
Ri405	VDD	VDD#17	    5.4000	$mt1
Ri406	VDD	VDD#18	    6.6600	$mt1
Ri407	VDD	VDD#19	    7.8480	$mt1
Ri408	VDD	VDD#20	    9.1080	$mt1
Ri409	VDD	VDD#21	   10.2960	$mt1
Ri410	VDD	VDD#22	   15.4290	$mt1
Ri411	VDD	VDD#23	   15.4290	$mt1
Ri412	VDD	VDD#24	   15.4290	$mt1
Ri413	VDD	VDD#25	   15.4290	$mt1
Ri414	VDD	VDD#26	   15.4290	$mt1
Ri415	VDD	VDD#27	   15.4290	$mt1
Ri416	VDD	VDD#28	   15.4290	$mt1
Ri417	VDD	VDD#29	   15.4290	$mt1
Ri418	VDD	VDD#30	   15.4290	$mt1
Ri419	VDD	VDD#31	   15.4290	$mt1
Ri420	VDD	VDD#32	   15.4290	$mt1
Ri421	VDD	VDD#33	   15.4290	$mt1
Ri422	VDD	VDD#34	   15.4290	$mt1
Ri423	VDD	VDD#35	   15.4290	$mt1
Ri424	VDD	VDD#36	   15.4290	$mt1
Ri425	VDD	VDD#37	   15.4290	$mt1
Ri426	VDD	VDD#38	   15.4290	$mt1
Ri427	VDD	VDD#39	   15.4290	$mt1
Ri428	VDD	VDD#40	   15.4290	$mt1
Ri429	VDD	VDD#41	   15.4290	$mt1
Ri430	VDD	VDD#42	   15.4290	$mt1
Ri431	VDD	VDD#43	   15.4290	$mt1
Ri432	VDD	VDD#44	   15.4290	$mt1
Ri433	VDD	VDD#45	   15.4290	$mt1
Ri434	VDD	VDD#46	   15.4290	$mt1
Ri435	VDD	VDD#47	   15.4290	$mt1
Ri436	VDD	VDD#48	   15.4290	$mt1
Ri437	VDD	VDD#49	   15.4290	$mt1
Ri438	VDD	VDD#50	   15.4290	$mt1
Ri439	VDD	VDD#51	   15.4290	$mt1
Ri440	VDD	VDD#52	   15.4290	$mt1
Ri441	VDD	VDD#53	   15.4290	$mt1
Ri442	VDD	VDD#54	   15.4290	$mt1
Ri443	VDD	VDD#55	   15.4290	$mt1
Ri444	VDD	VDD#56	   15.4290	$mt1
Ri445	VDD	VDD#57	   15.4290	$mt1
Ri446	VDD#21	VDD#58	   15.4201	$mt1
Ri447	VDD#59	VDD	   11.1600	$mt1
Ri448	VDD	VDD#60	   15.3296	$mt1
Ri449	VDD#2	VDD#3	    0.8824	$mt1
Ri450	VDD#2	VDD#4	    1.6667	$mt1
Ri451	VDD#2	VDD#5	    1.6667	$mt1
Ri452	VDD#2	VDD#6	    0.9375	$mt1
Ri453	VDD#2	VDD#7	    0.8824	$mt1
Ri454	VDD#2	VDD#8	    0.9375	$mt1
Ri455	VDD#2	VDD#9	    0.8824	$mt1
Ri456	VDD#2	VDD#10	    0.9375	$mt1
Ri457	VDD#2	VDD#11	    0.8824	$mt1
Ri458	VDD#2	VDD#12	    0.9375	$mt1
Ri459	VDD#2	VDD#13	    0.8824	$mt1
Ri460	VDD#2	VDD#14	    0.9375	$mt1
Ri461	VDD#2	VDD#15	    0.8824	$mt1
Ri462	VDD#2	VDD#16	    0.9375	$mt1
Ri463	VDD#2	VDD#17	    0.8824	$mt1
Ri464	VDD#2	VDD#18	    0.9375	$mt1
Ri465	VDD#2	VDD#19	    0.8824	$mt1
Ri466	VDD#2	VDD#20	    0.9375	$mt1
Ri467	VDD#2	VDD#21	    0.8824	$mt1
Ri468	VDD#2	VDD#59	    3.0000	$mt1
Ri469	GND#118	GND	   15.3650	$mt1
Ri470	GND#120	GND	   10.7280	$mt1
Ri471	GND#121	GND	    9.7200	$mt1
Ri472	GND#122	GND	    9.0000	$mt1
Ri473	GND#123	GND	    8.0280	$mt1
Ri474	GND#111	GND	    7.7760	$mt1
Ri475	GND#124	GND	    6.8400	$mt1
Ri476	GND#125	GND	    5.5800	$mt1
Ri477	GND#96	GND	    5.3280	$mt1
Ri478	GND#126	GND	    4.3920	$mt1
Ri479	GND#127	GND	    3.1320	$mt1
Ri480	GND#81	GND	    2.8800	$mt1
Ri481	GND#128	GND	    1.9440	$mt1
Ri482	GND#129	GND	    0.6840	$mt1
Ri483	GND#66	GND	    0.4320	$mt1
Ri484	GND	GND#130	    0.5040	$mt1
Ri485	GND	GND#131	    1.7640	$mt1
Ri486	GND	GND#51	    2.0160	$mt1
Ri487	GND	GND#132	    2.9520	$mt1
Ri488	GND	GND#133	    4.2120	$mt1
Ri489	GND	GND#36	    4.4640	$mt1
Ri490	GND	GND#134	    5.4000	$mt1
Ri491	GND	GND#135	    6.6600	$mt1
Ri492	GND	GND#21	    6.9120	$mt1
Ri493	GND	GND#136	    7.8480	$mt1
Ri494	GND	GND#137	    9.1080	$mt1
Ri495	GND	GND#10	   10.0800	$mt1
Ri496	GND	GND#138	   10.2960	$mt1
Ri497	GND	GND#139	   15.3650	$mt1
Ri498	GND	GND#140	   15.3650	$mt1
Ri499	GND	GND#141	   15.3650	$mt1
Ri500	GND	GND#142	   15.3650	$mt1
Ri501	GND	GND#143	   15.3650	$mt1
Ri502	GND	GND#144	   15.3650	$mt1
Ri503	GND	GND#145	   15.3650	$mt1
Ri504	GND	GND#146	   15.3650	$mt1
Ri505	GND	GND#147	   15.3650	$mt1
Ri506	GND	GND#148	   15.3650	$mt1
Ri507	GND	GND#149	   15.3650	$mt1
Ri508	GND	GND#150	   15.3650	$mt1
Ri509	GND	GND#151	   15.3650	$mt1
Ri510	GND	GND#152	   15.3650	$mt1
Ri511	GND	GND#153	   15.3650	$mt1
Ri512	GND	GND#154	   15.3650	$mt1
Ri513	GND	GND#155	   15.3650	$mt1
Ri514	GND	GND#156	   15.3650	$mt1
Ri515	GND	GND#157	   15.3650	$mt1
Ri516	GND	GND#158	   15.3650	$mt1
Ri517	GND#130	GND#159	   15.3268	$mt1
Ri518	GND	GND#160	   15.3650	$mt1
Ri519	GND	GND#161	   15.3650	$mt1
Ri520	GND	GND#162	   15.3650	$mt1
Ri521	GND#132	GND#163	   15.3268	$mt1
Ri522	GND	GND#164	   15.3650	$mt1
Ri523	GND	GND#165	   15.3650	$mt1
Ri524	GND	GND#166	   15.3650	$mt1
Ri525	GND#134	GND#167	   15.3268	$mt1
Ri526	GND	GND#168	   15.3650	$mt1
Ri527	GND	GND#169	   15.3650	$mt1
Ri528	GND	GND#170	   15.3650	$mt1
Ri529	GND#136	GND#171	   15.3268	$mt1
Ri530	GND	GND#172	   15.3650	$mt1
Ri531	GND	GND#173	   15.3650	$mt1
Ri532	GND	GND#174	   15.3650	$mt1
Ri533	GND#138	GND#175	   15.3026	$mt1
Ri534	GND	GND#176	   11.1600	$mt1
Ri535	GND#176	GND	    0.1412	$mt1
Ri536	GND	GND#177	   15.2656	$mt1
Ri537	GND	GND#178	   15.3650	$mt1
Ri538	GND#119	GND#120	    0.8824	$mt1
Ri539	GND#119	GND#121	    1.6667	$mt1
Ri540	GND#119	GND#122	    1.6667	$mt1
Ri541	GND#119	GND#123	    0.9375	$mt1
Ri542	GND#119	GND#124	    0.8824	$mt1
Ri543	GND#119	GND#125	    0.9375	$mt1
Ri544	GND#119	GND#126	    0.8824	$mt1
Ri545	GND#119	GND#127	    0.9375	$mt1
Ri546	GND#119	GND#128	    0.8824	$mt1
Ri547	GND#119	GND#129	    0.9375	$mt1
Ri548	GND#119	GND#130	    0.8824	$mt1
Ri549	GND#119	GND#131	    0.9375	$mt1
Ri550	GND#119	GND#132	    0.8824	$mt1
Ri551	GND#119	GND#133	    0.9375	$mt1
Ri552	GND#119	GND#134	    0.8824	$mt1
Ri553	GND#119	GND#135	    0.9375	$mt1
Ri554	GND#119	GND#136	    0.8824	$mt1
Ri555	GND#119	GND#137	    0.9375	$mt1
Ri556	GND#119	GND#138	    0.8824	$mt1
Ri557	GND#119	GND#176	    3.0000	$mt1
Rh1	avC13#6	avC13#2	    2.8600	$mt2
Rh2	CLK#10	CLK#3	    0.2160	$mt2
Rh4	avC14#7	avC14#5	    1.5080	$mt2
Rh5	avC14#5	avC14#4	    0.1080	$mt2
Rh6	avI5/avC12#7	avI5/avC12#8	    0.4320	$mt2
Rh7	avI5/avC12#8	avI5/avC12#2	    0.2160	$mt2
Rh8	avI5/avC12#4	avI5/avC12#8	    1.4000	$mt2
Rh9	avI5/avC10#6	avI5/avC10#4	    0.9720	$mt2
Rh10	avI5/avC10#4	avI5/avC10#2	    0.2160	$mt2
Rh11	avI5/avC9#8	avI5/avC9#4	    1.8320	$mt2
Rh12	avI5/avC9#4	avI5/avC9#2	    0.3240	$mt2
Rh13	avC13#18	avC13#13	    1.5120	$mt2
Rh14	avC13#13	avC13#16	    0.2160	$mt2
Rh15	avC13#16	avC13#9	    0.2160	$mt2
Rh16	CLK#24	CLK#21	    0.4320	$mt2
Rh17	CLK#21	CLK#18	    0.9720	$mt2
Rh18	CLK#18	CLK#14	    0.5400	$mt2
Rh19	RST#8	RST#9	    0.5400	$mt2
Rh20	RST#9	RST#3	    0.3240	$mt2
Rh21	avI5/avC13#6	avI5/avC13#7	    1.8320	$mt2
Rh22	avI5/avC13#7	avI5/avC13#2	    0.2160	$mt2
Rh23	avI5/avC13#4	avI5/avC13#7	    1.4000	$mt2
Rh24	avI5/avC11#6	avI5/avC11#4	    0.9720	$mt2
Rh25	avI5/avC11#4	avI5/avC11#2	    0.2160	$mt2
Rh26	GND#8	GND#9	    2.1577	$mt2
Rh27	GND#9	GND#3	    0.4297	$mt2
Rh28	GND#9	GND#10	    1.5055	$mt2
Rh29	Q0#10	Q0#6	    1.8320	$mt2
Rh30	Q0#6	Q0#12	    0.1080	$mt2
Rh31	Q0#12	Q0#2	    0.2160	$mt2
Rh32	Q0#20	Q0#19	    1.5080	$mt2
Rh33	Q0#19	Q0#16	    0.1080	$mt2
Rh34	avI6/avC12#6	avI6/avC12#7	    1.8320	$mt2
Rh35	avI6/avC12#7	avI6/avC12#2	    0.2160	$mt2
Rh36	avI6/avC12#4	avI6/avC12#7	    1.4000	$mt2
Rh37	avI6/avC10#6	avI6/avC10#4	    0.9720	$mt2
Rh38	avI6/avC10#4	avI6/avC10#2	    0.2160	$mt2
Rh39	avI6/avC9#8	avI6/avC9#4	    1.8320	$mt2
Rh40	avI6/avC9#4	avI6/avC9#2	    0.3240	$mt2
Rh41	avC13#31	avC13#26	    1.5120	$mt2
Rh42	avC13#26	avC13#29	    0.2160	$mt2
Rh43	avC13#29	avC13#22	    0.2160	$mt2
Rh44	CLK#37	CLK#34	    0.4320	$mt2
Rh45	CLK#34	CLK#31	    0.9720	$mt2
Rh46	CLK#31	CLK#27	    0.5400	$mt2
Rh47	GND#21	GND#22	    2.8000	$mt2
Rh48	GND#24	GND#19	    0.5400	$mt2
Rh49	GND#19	GND#15	    0.3240	$mt2
Rh50	avI6/avC13#6	avI6/avC13#7	    1.8320	$mt2
Rh51	avI6/avC13#7	avI6/avC13#2	    0.2160	$mt2
Rh52	avI6/avC13#4	avI6/avC13#7	    1.4000	$mt2
Rh53	avI6/avC11#6	avI6/avC11#4	    0.9720	$mt2
Rh54	avI6/avC11#4	avI6/avC11#2	    0.2160	$mt2
Rh55	RST#22	RST#20	    2.1600	$mt2
Rh56	RST#20	RST#15	    0.4320	$mt2
Rh57	Q1#10	Q1#6	    1.8320	$mt2
Rh58	Q1#6	Q1#12	    0.1080	$mt2
Rh59	Q1#12	Q1#2	    0.2160	$mt2
Rh60	Q1#20	Q1#18	    1.5080	$mt2
Rh61	Q1#18	Q1#17	    0.1080	$mt2
Rh62	avI7/avC12#6	avI7/avC12#7	    1.8320	$mt2
Rh63	avI7/avC12#7	avI7/avC12#2	    0.2160	$mt2
Rh64	avI7/avC12#4	avI7/avC12#7	    1.4000	$mt2
Rh65	avI7/avC10#6	avI7/avC10#4	    0.9720	$mt2
Rh66	avI7/avC10#4	avI7/avC10#2	    0.2160	$mt2
Rh67	avI7/avC9#8	avI7/avC9#4	    1.8320	$mt2
Rh68	avI7/avC9#4	avI7/avC9#2	    0.3240	$mt2
Rh69	avC13#44	avC13#39	    1.5120	$mt2
Rh70	avC13#39	avC13#42	    0.2160	$mt2
Rh71	avC13#42	avC13#35	    0.2160	$mt2
Rh72	CLK#50	CLK#47	    0.4320	$mt2
Rh73	CLK#47	CLK#44	    0.9720	$mt2
Rh74	CLK#44	CLK#40	    0.5400	$mt2
Rh75	GND#36	GND#37	    2.8000	$mt2
Rh76	GND#39	GND#34	    0.5400	$mt2
Rh77	GND#34	GND#30	    0.3240	$mt2
Rh78	avI7/avC13#6	avI7/avC13#7	    1.8320	$mt2
Rh79	avI7/avC13#7	avI7/avC13#2	    0.2160	$mt2
Rh80	avI7/avC13#4	avI7/avC13#7	    1.4000	$mt2
Rh81	avI7/avC11#6	avI7/avC11#4	    0.9720	$mt2
Rh82	avI7/avC11#4	avI7/avC11#2	    0.2160	$mt2
Rh83	RST#34	RST#32	    2.1600	$mt2
Rh84	RST#32	RST#27	    0.4320	$mt2
Rh85	Q2#10	Q2#6	    1.8320	$mt2
Rh86	Q2#6	Q2#12	    0.1080	$mt2
Rh87	Q2#12	Q2#2	    0.2160	$mt2
Rh88	Q2#20	Q2#18	    1.5080	$mt2
Rh89	Q2#18	Q2#17	    0.1080	$mt2
Rh90	avI8/avC12#6	avI8/avC12#7	    1.8320	$mt2
Rh91	avI8/avC12#7	avI8/avC12#2	    0.2160	$mt2
Rh92	avI8/avC12#4	avI8/avC12#7	    1.4000	$mt2
Rh93	avI8/avC10#6	avI8/avC10#4	    0.9720	$mt2
Rh94	avI8/avC10#4	avI8/avC10#2	    0.2160	$mt2
Rh95	avI8/avC9#8	avI8/avC9#4	    1.8320	$mt2
Rh96	avI8/avC9#4	avI8/avC9#2	    0.3240	$mt2
Rh97	avC13#57	avC13#52	    1.5120	$mt2
Rh98	avC13#52	avC13#55	    0.2160	$mt2
Rh99	avC13#55	avC13#48	    0.2160	$mt2
Rh100	CLK#63	CLK#60	    0.4320	$mt2
Rh101	CLK#60	CLK#57	    0.9720	$mt2
Rh102	CLK#57	CLK#53	    0.5400	$mt2
Rh103	GND#51	GND#52	    2.8000	$mt2
Rh104	GND#54	GND#49	    0.5400	$mt2
Rh105	GND#49	GND#45	    0.3240	$mt2
Rh106	avI8/avC13#6	avI8/avC13#7	    1.8320	$mt2
Rh107	avI8/avC13#7	avI8/avC13#2	    0.2160	$mt2
Rh108	avI8/avC13#4	avI8/avC13#7	    1.4000	$mt2
Rh109	avI8/avC11#6	avI8/avC11#4	    0.9720	$mt2
Rh110	avI8/avC11#4	avI8/avC11#2	    0.2160	$mt2
Rh111	RST#46	RST#44	    2.1600	$mt2
Rh112	RST#44	RST#39	    0.4320	$mt2
Rh113	Q3#10	Q3#6	    1.8320	$mt2
Rh114	Q3#6	Q3#12	    0.1080	$mt2
Rh115	Q3#12	Q3#2	    0.2160	$mt2
Rh116	Q3#20	Q3#18	    1.5080	$mt2
Rh117	Q3#18	Q3#17	    0.1080	$mt2
Rh118	avI9/avC12#6	avI9/avC12#7	    1.8320	$mt2
Rh119	avI9/avC12#7	avI9/avC12#2	    0.2160	$mt2
Rh120	avI9/avC12#4	avI9/avC12#7	    1.4000	$mt2
Rh121	avI9/avC10#6	avI9/avC10#4	    0.9720	$mt2
Rh122	avI9/avC10#4	avI9/avC10#2	    0.2160	$mt2
Rh123	avI9/avC9#8	avI9/avC9#4	    1.8320	$mt2
Rh124	avI9/avC9#4	avI9/avC9#2	    0.3240	$mt2
Rh125	avC13#70	avC13#65	    1.5120	$mt2
Rh126	avC13#65	avC13#68	    0.2160	$mt2
Rh127	avC13#68	avC13#61	    0.2160	$mt2
Rh128	CLK#76	CLK#73	    0.4320	$mt2
Rh129	CLK#73	CLK#70	    0.9720	$mt2
Rh130	CLK#70	CLK#66	    0.5400	$mt2
Rh131	GND#66	GND#67	    2.8000	$mt2
Rh132	GND#69	GND#64	    0.5400	$mt2
Rh133	GND#64	GND#60	    0.3240	$mt2
Rh134	avI9/avC13#6	avI9/avC13#7	    1.8320	$mt2
Rh135	avI9/avC13#7	avI9/avC13#2	    0.2160	$mt2
Rh136	avI9/avC13#4	avI9/avC13#7	    1.4000	$mt2
Rh137	avI9/avC11#6	avI9/avC11#4	    0.9720	$mt2
Rh138	avI9/avC11#4	avI9/avC11#2	    0.2160	$mt2
Rh139	RST#58	RST#56	    2.1600	$mt2
Rh140	RST#56	RST#51	    0.4320	$mt2
Rh141	Q4#10	Q4#6	    1.8320	$mt2
Rh142	Q4#6	Q4#12	    0.1080	$mt2
Rh143	Q4#12	Q4#2	    0.2160	$mt2
Rh144	Q4#20	Q4#18	    1.5080	$mt2
Rh145	Q4#18	Q4#17	    0.1080	$mt2
Rh146	avI10/avC12#6	avI10/avC12#7	    1.8320	$mt2
Rh147	avI10/avC12#7	avI10/avC12#2	    0.2160	$mt2
Rh148	avI10/avC12#4	avI10/avC12#7	    1.4000	$mt2
Rh149	avI10/avC10#6	avI10/avC10#4	    0.9720	$mt2
Rh150	avI10/avC10#4	avI10/avC10#2	    0.2160	$mt2
Rh151	avI10/avC9#8	avI10/avC9#4	    1.8320	$mt2
Rh152	avI10/avC9#4	avI10/avC9#2	    0.3240	$mt2
Rh153	avC13#83	avC13#78	    1.5120	$mt2
Rh154	avC13#78	avC13#81	    0.2160	$mt2
Rh155	avC13#81	avC13#74	    0.2160	$mt2
Rh156	CLK#89	CLK#86	    0.4320	$mt2
Rh157	CLK#86	CLK#83	    0.9720	$mt2
Rh158	CLK#83	CLK#79	    0.5400	$mt2
Rh159	GND#81	GND#82	    2.8000	$mt2
Rh160	GND#84	GND#79	    0.5400	$mt2
Rh161	GND#79	GND#75	    0.3240	$mt2
Rh162	avI10/avC13#6	avI10/avC13#7	    1.8320	$mt2
Rh163	avI10/avC13#7	avI10/avC13#2	    0.2160	$mt2
Rh164	avI10/avC13#4	avI10/avC13#7	    1.4000	$mt2
Rh165	avI10/avC11#6	avI10/avC11#4	    0.9720	$mt2
Rh166	avI10/avC11#4	avI10/avC11#2	    0.2160	$mt2
Rh167	RST#70	RST#68	    2.1600	$mt2
Rh168	RST#68	RST#63	    0.4320	$mt2
Rh169	Q5#10	Q5#6	    1.8320	$mt2
Rh170	Q5#6	Q5#12	    0.1080	$mt2
Rh171	Q5#12	Q5#2	    0.2160	$mt2
Rh172	Q5#20	Q5#18	    1.5080	$mt2
Rh173	Q5#18	Q5#17	    0.1080	$mt2
Rh174	avI11/avC12#6	avI11/avC12#7	    1.8320	$mt2
Rh175	avI11/avC12#7	avI11/avC12#2	    0.2160	$mt2
Rh176	avI11/avC12#4	avI11/avC12#7	    1.4000	$mt2
Rh177	avI11/avC10#6	avI11/avC10#4	    0.9720	$mt2
Rh178	avI11/avC10#4	avI11/avC10#2	    0.2160	$mt2
Rh179	avI11/avC9#8	avI11/avC9#4	    1.8320	$mt2
Rh180	avI11/avC9#4	avI11/avC9#2	    0.3240	$mt2
Rh181	avC13#96	avC13#91	    1.5120	$mt2
Rh182	avC13#91	avC13#94	    0.2160	$mt2
Rh183	avC13#94	avC13#87	    0.2160	$mt2
Rh184	CLK#102	CLK#99	    0.4320	$mt2
Rh185	CLK#99	CLK#96	    0.9720	$mt2
Rh186	CLK#96	CLK#92	    0.5400	$mt2
Rh187	GND#96	GND#97	    2.8000	$mt2
Rh188	GND#99	GND#94	    0.5400	$mt2
Rh189	GND#94	GND#90	    0.3240	$mt2
Rh190	avI11/avC13#6	avI11/avC13#7	    1.8320	$mt2
Rh191	avI11/avC13#7	avI11/avC13#2	    0.2160	$mt2
Rh192	avI11/avC13#4	avI11/avC13#7	    1.4000	$mt2
Rh193	avI11/avC11#6	avI11/avC11#4	    0.9720	$mt2
Rh194	avI11/avC11#4	avI11/avC11#2	    0.2160	$mt2
Rh195	RST#82	RST#80	    2.1600	$mt2
Rh196	RST#80	RST#75	    0.4320	$mt2
Rh197	Q6#10	Q6#6	    1.8320	$mt2
Rh198	Q6#6	Q6#12	    0.1080	$mt2
Rh199	Q6#12	Q6#2	    0.2160	$mt2
Rh200	Q6#20	Q6#19	    1.5080	$mt2
Rh201	Q6#19	Q6#16	    0.1080	$mt2
Rh202	avI12/avC12#6	avI12/avC12#7	    1.8320	$mt2
Rh203	avI12/avC12#7	avI12/avC12#2	    0.2160	$mt2
Rh204	avI12/avC12#4	avI12/avC12#7	    1.4000	$mt2
Rh205	avI12/avC10#6	avI12/avC10#4	    0.9720	$mt2
Rh206	avI12/avC10#4	avI12/avC10#2	    0.2160	$mt2
Rh207	avI12/avC9#8	avI12/avC9#4	    1.8320	$mt2
Rh208	avI12/avC9#4	avI12/avC9#2	    0.3240	$mt2
Rh209	avC13#109	avC13#104	    1.5120	$mt2
Rh210	avC13#104	avC13#107	    0.2160	$mt2
Rh211	avC13#107	avC13#100	    0.2160	$mt2
Rh212	CLK#115	CLK#112	    0.4320	$mt2
Rh213	CLK#112	CLK#109	    0.9720	$mt2
Rh214	CLK#109	CLK#105	    0.5400	$mt2
Rh215	GND#111	GND#112	    2.8000	$mt2
Rh216	GND#114	GND#109	    0.5400	$mt2
Rh217	GND#109	GND#105	    0.3240	$mt2
Rh218	avI12/avC13#6	avI12/avC13#7	    1.8320	$mt2
Rh219	avI12/avC13#7	avI12/avC13#2	    0.2160	$mt2
Rh220	avI12/avC13#4	avI12/avC13#7	    1.4000	$mt2
Rh221	avI12/avC11#6	avI12/avC11#4	    0.9720	$mt2
Rh222	avI12/avC11#4	avI12/avC11#2	    0.2160	$mt2
Rh223	RST#94	RST#92	    2.1600	$mt2
Rh224	RST#92	RST#87	    0.4320	$mt2
Rh225	Q7#10	Q7#6	    1.8320	$mt2
Rh226	Q7#6	Q7#12	    0.1080	$mt2
Rh227	Q7#12	Q7#2	    0.2160	$mt2
Rh228	avC15#5	avC15#6	    0.1080	$mt2
Rh229	avC15#6	avC15#2	    0.1080	$mt2
Rh230	avI2/avC6#7	avI2/avC6#4	    0.3240	$mt2
Rh231	avI2/avC6#4	avI2/avC6#2	    0.3240	$mt2
Rh232	Q0#31	Q0#26	    0.3240	$mt2
Rh233	Q0#26	Q0#24	    0.3240	$mt2
Rh236	Q5#30	Q5#25	    0.3240	$mt2
Rh237	Q5#25	Q5#23	    0.3240	$mt2
Rh238	avC16#5	avC16#6	    0.1080	$mt2
Rh239	avC16#6	avC16#2	    0.1080	$mt2
Rh240	avI3/avC6#7	avI3/avC6#4	    0.3240	$mt2
Rh241	avI3/avC6#4	avI3/avC6#2	    0.3240	$mt2
Rh242	Q6#31	Q6#28	    0.3240	$mt2
Rh243	Q6#28	Q6#24	    0.3240	$mt2
Rh246	Q7#22	Q7#17	    0.3240	$mt2
Rh247	Q7#17	Q7#15	    0.3240	$mt2
Rh248	avI4/avC6#6	avI4/avC6#4	    0.3240	$mt2
Rh249	avI4/avC6#4	avI4/avC6#2	    0.2160	$mt2
Rh250	avC14#13	avC14#14	    0.1080	$mt2
Rh251	avC14#14	avC14#10	    0.1080	$mt2
Rh252	avC16#16	avC16#13	    1.0800	$mt2
Rh253	avC16#13	avC16#9	    1.4000	$mt2
Rh254	avI4/avC10#5	avI4/avC10#3	    1.8320	$mt2
Rh255	avI4/avC10#3	avI4/avC10	    0.4320	$mt2
Rh256	avC15#14	avC15#15	    0.2160	$mt2
Rh257	avC15#15	avC15#9	    0.4320	$mt2
Rh258	avI4/avC7#8	avI4/avC7#6	    0.2160	$mt2
Rh259	avI4/avC7#6	avI4/avC7#2	    0.7560	$mt2
Rg1	CLK#4	CLK#3	    3.3320	$mt3
Rg2	avC13#7	avC13#6	    1.7000	$mt3
Rg3	avC14#5	avC14#6	    3.1960	$mt3
Rg4	avC13#15	avC13#16	    2.8480	$mt3
Rg5	CLK#17	CLK#18	    2.8480	$mt3
Rg6	RST#9	RST#12	    3.4280	$mt3
Rg7	Q0#17	Q0#12	    3.2160	$mt3
Rg8	Q0#18	Q0#19	    2.8480	$mt3
Rg9	avC13#28	avC13#29	    2.8480	$mt3
Rg10	CLK#30	CLK#31	    2.8480	$mt3
Rg11	RST#19	RST#20	    2.8680	$mt3
Rg12	GND#19	GND#20	    3.3120	$mt3
Rg13	GND#27	GND#22	    1.7360	$mt3
Rg14	Q1#13	Q1#12	    2.8480	$mt3
Rg15	Q1#18	Q1#19	    3.3120	$mt3
Rg16	avC13#41	avC13#42	    2.8480	$mt3
Rg17	CLK#43	CLK#44	    2.8480	$mt3
Rg18	RST#31	RST#32	    2.8680	$mt3
Rg19	GND#34	GND#35	    3.3120	$mt3
Rg20	GND#42	GND#37	    1.7360	$mt3
Rg21	Q2#13	Q2#12	    2.8480	$mt3
Rg22	Q2#18	Q2#19	    3.3120	$mt3
Rg23	avC13#54	avC13#55	    2.8480	$mt3
Rg24	CLK#56	CLK#57	    2.8480	$mt3
Rg25	RST#43	RST#44	    2.8680	$mt3
Rg26	GND#49	GND#50	    3.3120	$mt3
Rg27	GND#57	GND#52	    1.7360	$mt3
Rg28	Q3#13	Q3#12	    2.8480	$mt3
Rg29	Q3#18	Q3#19	    3.3120	$mt3
Rg30	avC13#67	avC13#68	    2.8480	$mt3
Rg31	CLK#69	CLK#70	    2.8480	$mt3
Rg32	RST#55	RST#56	    2.8680	$mt3
Rg33	GND#64	GND#65	    3.3120	$mt3
Rg34	GND#72	GND#67	    1.7360	$mt3
Rg35	Q4#13	Q4#12	    2.8480	$mt3
Rg36	Q4#18	Q4#19	    3.3120	$mt3
Rg37	avC13#80	avC13#81	    2.8480	$mt3
Rg38	CLK#82	CLK#83	    2.8480	$mt3
Rg39	RST#67	RST#68	    2.8680	$mt3
Rg40	GND#79	GND#80	    3.3120	$mt3
Rg41	GND#87	GND#82	    1.7360	$mt3
Rg42	Q5#13	Q5#12	    2.8480	$mt3
Rg43	Q5#18	Q5#19	    3.3120	$mt3
Rg44	avC13#93	avC13#94	    2.8480	$mt3
Rg45	CLK#95	CLK#96	    2.8480	$mt3
Rg46	RST#79	RST#80	    2.8680	$mt3
Rg47	GND#94	GND#95	    3.5440	$mt3
Rg48	GND#102	GND#97	    1.5040	$mt3
Rg49	Q6#17	Q6#12	    3.3320	$mt3
Rg50	Q6#18	Q6#19	    2.8680	$mt3
Rg51	avC13#106	avC13#107	    2.8480	$mt3
Rg52	CLK#108	CLK#109	    2.8480	$mt3
Rg53	RST#91	RST#92	    2.8680	$mt3
Rg54	GND#109	GND#110	    3.0800	$mt3
Rg55	GND#117	GND#112	    1.9680	$mt3
Rg56	Q7#12	Q7#13	    2.9640	$mt3
Rg57	Q0#28	Q0#24	    2.8680	$mt3
Rg58	avC15#7	avC15#6	    2.8680	$mt3
Rg59	Q5#32	Q5#30	    2.8480	$mt3
Rg60	Q6#26	Q6#24	    2.9840	$mt3
Rg61	avC16#6	avC16#7	    2.9640	$mt3
Rg62	Q7#22	Q7#24	    2.9640	$mt3
Rg63	avC16#13	avC16#14	    2.9640	$mt3
Rg64	avC14#15	avC14#14	    2.9840	$mt3
Rg65	avC15#19	avC15#15	    2.8480	$mt3
Rf1	GND#27	GND#20	    0.3240	$mt4
Rf2	Q1#19	Q1	    0.4318	$mt4
Rf3	Q1	Q1#13	    0.4320	$mt4
Rf4	GND#42	GND#35	    0.3240	$mt4
Rf5	Q2#19	Q2	    0.4318	$mt4
Rf6	Q2	Q2#13	    0.4320	$mt4
Rf7	GND#57	GND#50	    0.3240	$mt4
Rf8	Q3#19	Q3	    0.4318	$mt4
Rf9	Q3	Q3#13	    0.4320	$mt4
Rf10	GND#72	GND#65	    0.3240	$mt4
Rf11	Q4#19	Q4	    0.4318	$mt4
Rf12	Q4	Q4#13	    0.4320	$mt4
Rf13	GND#87	GND#80	    0.3240	$mt4
Rf14	GND#102	GND#95	    0.3240	$mt4
Rf15	avC13#106	avC13#93	    3.6720	$mt4
Rf16	avC13#93	avC13#80	    3.6720	$mt4
Rf17	avC13#80	avC13#67	    3.6720	$mt4
Rf18	avC13#67	avC13#54	    3.6720	$mt4
Rf19	avC13#54	avC13#41	    3.6720	$mt4
Rf20	avC13#41	avC13#28	    3.6720	$mt4
Rf21	avC13#28	avC13#15	    3.6720	$mt4
Rf22	avC13#15	avC13#7	    0.6960	$mt4
Rf23	CLK#108	CLK#95	    3.6720	$mt4
Rf24	CLK#95	CLK#82	    3.6720	$mt4
Rf25	CLK#82	CLK#69	    3.6720	$mt4
Rf26	CLK#69	CLK	    2.5378	$mt4
Rf27	CLK	CLK#56	    1.1340	$mt4
Rf28	CLK#56	CLK#43	    3.6720	$mt4
Rf29	CLK#43	CLK#30	    3.6720	$mt4
Rf30	CLK#30	CLK#17	    3.6720	$mt4
Rf31	CLK#17	CLK#4	    1.4040	$mt4
Rf32	RST#91	RST#79	    3.6720	$mt4
Rf33	RST#79	RST#67	    3.6720	$mt4
Rf34	RST#67	RST#55	    3.6720	$mt4
Rf35	RST#55	RST	    1.4578	$mt4
Rf36	RST	RST#43	    2.2140	$mt4
Rf37	RST#43	RST#31	    3.6720	$mt4
Rf38	RST#31	RST#19	    3.6720	$mt4
Rf39	RST#19	RST#12	    2.9160	$mt4
Rf40	GND#117	GND#110	    0.3240	$mt4
Rf41	Q0#28	Q0	   13.2838	$mt4
Rf42	Q0	Q0#18	   12.4200	$mt4
Rf43	Q0#18	Q0#17	    0.8640	$mt4
Rf44	Q5#32	Q5	    4.4818	$mt4
Rf45	Q5	Q5#19	    3.6180	$mt4
Rf46	Q5#19	Q5#13	    0.8640	$mt4
Rf47	Q6#26	Q6	    2.8078	$mt4
Rf48	Q6	Q6#18	    1.9440	$mt4
Rf49	Q6#18	Q6#17	    0.8640	$mt4
Rf50	Q7#24	Q7	    1.3498	$mt4
Rf51	Q7	Q7#13	    1.3500	$mt4
Rf52	avC16#14	avC16#7	    0.6480	$mt4
Rf53	avC14#15	avC14#6	   32.1840	$mt4
Rf54	avC15#19	avC15#7	    3.0240	$mt4
*
*       CAPACITOR CARDS
*
*
C1	VDD	GND	4.086E-15
C2	CLK	GND	9.104E-16
C3	Q0	GND	4.302E-15
C4	Q1	GND	2.105E-16
C5	Q2	GND	2.105E-16
C6	Q3	GND	2.105E-16
C7	Q4	GND	2.105E-16
C8	Q5	GND	1.879E-15
C9	Q6	GND	7.913E-16
C10	Q7	GND	3.990E-16
C11	RST	GND	4.791E-16
C12	avC13	GND	1.294E-16
C13	avC15	GND	1.016E-16
C14	avC16	GND	1.043E-16
C15	avC14	GND	1.158E-18
C16	avI12/avC17	GND	5.511E-18
C17	avI12/avC16	GND	9.037E-18
C18	avI12/avC15	GND	1.563E-17
C19	avI12/avC14	GND	8.502E-18
C20	avI12/avC13	GND	5.299E-17
C21	avI12/avC12	GND	4.721E-17
C22	avI12/avC11	GND	7.458E-17
C23	avI12/avC10	GND	8.145E-17
C24	avI12/avC9	GND	9.494E-17
C25	avI11/avC17	GND	5.863E-18
C26	avI11/avC16	GND	2.055E-17
C27	avI11/avC15	GND	1.916E-17
C28	avI11/avC14	GND	1.599E-17
C29	avI11/avC13	GND	4.054E-17
C30	avI11/avC12	GND	4.721E-17
C31	avI11/avC11	GND	7.306E-17
C32	avI11/avC10	GND	8.286E-17
C33	avI11/avC9	GND	9.308E-17
C34	avI10/avC17	GND	1.825E-17
C35	avI10/avC16	GND	2.055E-17
C36	avI10/avC15	GND	1.916E-17
C37	avI10/avC14	GND	1.664E-17
C38	avI10/avC13	GND	4.291E-17
C39	avI10/avC12	GND	4.683E-17
C40	avI10/avC11	GND	7.924E-17
C41	avI10/avC10	GND	8.169E-17
C42	avI10/avC9	GND	9.338E-17
C43	avI9/avC17	GND	1.825E-17
C44	avI9/avC16	GND	2.055E-17
C45	avI9/avC15	GND	1.916E-17
C46	avI9/avC14	GND	1.664E-17
C47	avI9/avC13	GND	4.291E-17
C48	avI9/avC12	GND	4.682E-17
C49	avI9/avC11	GND	7.924E-17
C50	avI9/avC10	GND	8.169E-17
C51	avI9/avC9	GND	9.338E-17
C52	avI8/avC17	GND	1.823E-17
C53	avI8/avC16	GND	2.055E-17
C54	avI8/avC15	GND	1.894E-17
C55	avI8/avC14	GND	1.664E-17
C56	avI8/avC13	GND	4.291E-17
C57	avI8/avC12	GND	4.683E-17
C58	avI8/avC11	GND	7.924E-17
C59	avI8/avC10	GND	8.169E-17
C60	avI8/avC9	GND	9.338E-17
C61	avI7/avC17	GND	1.825E-17
C62	avI7/avC16	GND	2.030E-17
C63	avI7/avC15	GND	1.916E-17
C64	avI7/avC14	GND	1.664E-17
C65	avI7/avC13	GND	4.291E-17
C66	avI7/avC12	GND	4.683E-17
C67	avI7/avC11	GND	7.924E-17
C68	avI7/avC10	GND	8.169E-17
C69	avI7/avC9	GND	9.338E-17
C70	avI6/avC17	GND	1.825E-17
C71	avI6/avC16	GND	2.055E-17
C72	avI6/avC15	GND	1.916E-17
C73	avI6/avC14	GND	1.664E-17
C74	avI6/avC13	GND	4.291E-17
C75	avI6/avC12	GND	4.683E-17
C76	avI6/avC11	GND	7.924E-17
C77	avI6/avC10	GND	7.981E-17
C78	avI6/avC9	GND	9.307E-17
C79	avI5/avC17	GND	1.825E-17
C80	avI5/avC16	GND	1.520E-17
C81	avI5/avC15	GND	1.081E-17
C82	avI5/avC14	GND	8.347E-18
C83	avI5/avC13	GND	4.482E-17
C84	avI5/avC12	GND	4.049E-17
C85	avI5/avC11	GND	7.463E-17
C86	avI5/avC10	GND	6.965E-17
C87	avI5/avC9	GND	9.310E-17
C88	avI4/avC10	GND	1.272E-16
C89	avI4/avC8	GND	1.934E-17
C90	avI4/avC7	GND	1.055E-16
C91	avI4/avC6	GND	8.393E-17
C92	avI3/avC6	GND	1.333E-16
C93	avI2/avC6	GND	1.354E-16
C94	CLK#6	GND	4.598E-17
C95	CLK#11	GND	4.772E-17
C96	CLK#15	GND	5.549E-17
C97	avC13#14	GND	5.845E-17
C98	avI5/avC9#5	GND	6.222E-17
C99	avI5/avC10#7	GND	5.866E-17
C100	RST#4	GND	4.000E-17
C101	avC13#19	GND	5.293E-17
C102	CLK#25	GND	5.491E-17
C103	RST#10	GND	4.192E-17
C104	Q0#7	GND	5.670E-17
C105	avI5/avC11#7	GND	6.322E-17
C106	CLK#28	GND	5.098E-17
C107	avC13#27	GND	5.865E-17
C108	RST#16	GND	5.588E-17
C109	avI6/avC9#5	GND	6.186E-17
C110	avI6/avC10#7	GND	5.853E-17
C111	avC13#32	GND	5.122E-17
C112	CLK#38	GND	5.320E-17
C113	Q1#7	GND	5.891E-17
C114	avI6/avC11#7	GND	6.446E-17
C115	RST#23	GND	6.185E-17
C116	CLK#41	GND	5.548E-17
C117	avC13#40	GND	5.865E-17
C118	RST#28	GND	5.588E-17
C119	avI7/avC9#5	GND	6.186E-17
C120	avI7/avC10#7	GND	5.853E-17
C121	avC13#45	GND	5.122E-17
C122	CLK#51	GND	5.320E-17
C123	Q2#7	GND	5.895E-17
C124	avI7/avC11#7	GND	6.446E-17
C125	RST#35	GND	6.185E-17
C126	CLK#54	GND	5.548E-17
C127	avC13#53	GND	5.865E-17
C128	RST#40	GND	5.588E-17
C129	avI8/avC9#5	GND	6.186E-17
C130	avI8/avC10#7	GND	5.854E-17
C131	avC13#58	GND	5.122E-17
C132	CLK#64	GND	5.320E-17
C133	Q3#7	GND	5.893E-17
C134	avI8/avC11#7	GND	6.446E-17
C135	RST#47	GND	6.185E-17
C136	CLK#67	GND	5.548E-17
C137	avC13#66	GND	5.865E-17
C138	RST#52	GND	5.588E-17
C139	avI9/avC9#5	GND	6.186E-17
C140	avI9/avC10#7	GND	5.853E-17
C141	avC13#71	GND	5.122E-17
C142	CLK#77	GND	5.320E-17
C143	Q4#7	GND	5.891E-17
C144	avI9/avC11#7	GND	6.446E-17
C145	RST#59	GND	6.185E-17
C146	CLK#80	GND	5.548E-17
C147	avC13#79	GND	5.865E-17
C148	RST#64	GND	5.588E-17
C149	avI10/avC9#5	GND	6.186E-17
C150	avI10/avC10#7	GND	5.853E-17
C151	avC13#84	GND	5.122E-17
C152	CLK#90	GND	5.320E-17
C153	Q5#7	GND	5.891E-17
C154	avI10/avC11#7	GND	6.446E-17
C155	RST#71	GND	6.185E-17
C156	CLK#93	GND	5.548E-17
C157	avC13#92	GND	5.865E-17
C158	RST#76	GND	5.564E-17
C159	avI11/avC9#5	GND	6.186E-17
C160	avI11/avC10#7	GND	5.853E-17
C161	avC13#97	GND	5.122E-17
C162	CLK#103	GND	5.494E-17
C163	Q6#7	GND	5.711E-17
C164	avI11/avC11#7	GND	6.406E-17
C165	RST#83	GND	5.746E-17
C166	CLK#106	GND	5.165E-17
C167	avC13#105	GND	5.908E-17
C168	RST#88	GND	5.661E-17
C169	avI12/avC9#5	GND	6.461E-17
C170	avI12/avC10#7	GND	6.202E-17
C171	avC13#110	GND	5.103E-17
C172	CLK#116	GND	5.323E-17
C173	Q7#7	GND	6.242E-17
C174	avI12/avC11#7	GND	6.382E-17
C175	RST#95	GND	6.277E-17
C176	Q0#25	GND	6.396E-17
C177	Q5#26	GND	6.914E-17
C178	Q0#32	GND	5.104E-17
C179	Q6#25	GND	6.180E-17
C180	Q7#18	GND	6.954E-17
C181	Q6#32	GND	5.188E-17
C182	avC16#11	GND	5.734E-17
C183	avI4/avC6#7	GND	6.633E-17
C184	avI4/avC7#3	GND	6.500E-17
C185	avC15#10	GND	5.729E-17
C186	avC16#17	GND	6.876E-17
C187	avC15#16	GND	6.490E-17
C188	CLK#8	GND	3.392E-17
C189	CLK#12	GND	4.730E-17
C190	avC13#10	GND	5.430E-17
C191	CLK#16	GND	5.856E-17
C192	avI5/avC9#6	GND	5.215E-17
C193	avI5/avC10#8	GND	5.397E-17
C194	RST#6	GND	5.816E-17
C195	CLK#22	GND	5.795E-17
C196	avC13#20	GND	6.055E-17
C197	RST#11	GND	5.903E-17
C198	Q0#8	GND	5.413E-17
C199	avI5/avC11#8	GND	5.615E-17
C200	avC13#23	GND	5.509E-17
C201	CLK#29	GND	5.899E-17
C202	RST#18	GND	5.944E-17
C203	avI6/avC9#6	GND	5.362E-17
C204	avI6/avC10#8	GND	5.629E-17
C205	CLK#35	GND	5.873E-17
C206	avC13#33	GND	5.620E-17
C207	Q1#8	GND	5.413E-17
C208	avI6/avC11#8	GND	5.782E-17
C209	RST#24	GND	5.842E-17
C210	avC13#36	GND	5.585E-17
C211	CLK#42	GND	5.911E-17
C212	RST#30	GND	5.944E-17
C213	avI7/avC9#6	GND	5.502E-17
C214	avI7/avC10#8	GND	5.629E-17
C215	CLK#48	GND	5.873E-17
C216	avC13#46	GND	5.620E-17
C217	Q2#8	GND	5.413E-17
C218	avI7/avC11#8	GND	5.782E-17
C219	RST#36	GND	5.842E-17
C220	avC13#49	GND	5.585E-17
C221	CLK#55	GND	5.911E-17
C222	RST#42	GND	5.944E-17
C223	avI8/avC9#6	GND	5.502E-17
C224	avI8/avC10#8	GND	5.629E-17
C225	CLK#61	GND	5.873E-17
C226	avC13#59	GND	5.620E-17
C227	Q3#8	GND	5.413E-17
C228	avI8/avC11#8	GND	5.782E-17
C229	RST#48	GND	5.842E-17
C230	avC13#62	GND	5.585E-17
C231	CLK#68	GND	5.911E-17
C232	RST#54	GND	5.944E-17
C233	avI9/avC9#6	GND	5.502E-17
C234	avI9/avC10#8	GND	5.629E-17
C235	CLK#74	GND	5.873E-17
C236	avC13#72	GND	5.620E-17
C237	Q4#8	GND	5.413E-17
C238	avI9/avC11#8	GND	5.782E-17
C239	RST#60	GND	5.842E-17
C240	avC13#75	GND	5.585E-17
C241	CLK#81	GND	5.911E-17
C242	RST#66	GND	5.944E-17
C243	avI10/avC9#6	GND	5.502E-17
C244	avI10/avC10#8	GND	5.629E-17
C245	CLK#87	GND	5.873E-17
C246	avC13#85	GND	5.620E-17
C247	Q5#8	GND	5.413E-17
C248	avI10/avC11#8	GND	5.784E-17
C249	RST#72	GND	5.842E-17
C250	avC13#88	GND	5.582E-17
C251	CLK#94	GND	6.105E-17
C252	RST#78	GND	5.936E-17
C253	avI11/avC9#6	GND	5.440E-17
C254	avI11/avC10#8	GND	5.798E-17
C255	CLK#100	GND	6.064E-17
C256	avC13#98	GND	5.394E-17
C257	Q6#8	GND	5.537E-17
C258	avI11/avC11#8	GND	5.785E-17
C259	RST#84	GND	5.842E-17
C260	avC13#101	GND	5.670E-17
C261	CLK#107	GND	6.090E-17
C262	RST#90	GND	5.936E-17
C263	avI12/avC9#6	GND	5.440E-17
C264	avI12/avC10#8	GND	5.655E-17
C265	CLK#113	GND	6.075E-17
C266	avC13#111	GND	5.763E-17
C267	Q7#8	GND	5.487E-17
C268	avI12/avC11#8	GND	6.058E-17
C269	RST#96	GND	4.548E-17
C270	avI2/avC6#5	GND	4.519E-17
C271	Q5#27	GND	5.980E-17
C272	Q0#33	GND	6.118E-17
C273	avI3/avC6#5	GND	4.604E-17
C274	Q7#19	GND	5.882E-17
C275	Q6#33	GND	5.846E-17
C276	avC16#12	GND	5.530E-17
C277	avI4/avC6#8	GND	5.588E-17
C278	avI4/avC7#4	GND	5.257E-17
C279	avC15#11	GND	5.751E-17
C280	avC16#18	GND	5.861E-17
C281	avC15#18	GND	5.784E-17
C282	avC13#6	GND	8.201E-17
C283	avC14#5	GND	6.822E-17
C284	avC13#16	GND	1.103E-16
C285	CLK#18	GND	2.564E-16
C286	RST#9	GND	2.253E-16
C287	Q0#12	GND	1.259E-16
C288	Q0#19	GND	2.235E-17
C289	avC13#29	GND	1.099E-16
C290	CLK#31	GND	2.580E-16
C291	RST#20	GND	3.810E-16
C292	Q1#12	GND	7.060E-17
C293	Q1#18	GND	8.881E-17
C294	avC13#42	GND	1.099E-16
C295	CLK#44	GND	2.580E-16
C296	RST#32	GND	3.810E-16
C297	Q2#12	GND	7.060E-17
C298	Q2#18	GND	8.881E-17
C299	avC13#55	GND	1.099E-16
C300	CLK#57	GND	2.580E-16
C301	RST#44	GND	3.810E-16
C302	Q3#12	GND	7.060E-17
C303	Q3#18	GND	8.881E-17
C304	avC13#68	GND	1.099E-16
C305	CLK#70	GND	2.580E-16
C306	RST#56	GND	3.810E-16
C307	Q4#12	GND	7.060E-17
C308	Q4#18	GND	8.881E-17
C309	avC13#81	GND	1.099E-16
C310	CLK#83	GND	2.580E-16
C311	RST#68	GND	3.810E-16
C312	Q5#12	GND	7.060E-17
C313	Q5#18	GND	8.881E-17
C314	avC13#94	GND	1.099E-16
C315	CLK#96	GND	2.568E-16
C316	RST#80	GND	3.869E-16
C317	Q6#12	GND	1.410E-16
C318	Q6#19	GND	5.584E-17
C319	avC13#107	GND	1.104E-16
C320	CLK#109	GND	2.702E-16
C321	RST#92	GND	3.896E-16
C322	Q7#12	GND	1.013E-16
C323	avC15#6	GND	7.921E-17
C324	avC16#6	GND	6.948E-17
C325	avC16#13	GND	2.586E-16
C326	avC14#14	GND	5.782E-17
C327	avC15#15	GND	1.115E-16
C328	CLK#1	GND	1.265E-16
C329	CLK#9	GND	1.434E-16
C330	avC13#8	GND	1.565E-16
C331	CLK#13	GND	1.763E-16
C332	avC13#11	GND	1.495E-16
C333	avI5/avC10#5	GND	5.767E-17
C334	RST#1	GND	1.952E-16
C335	CLK#19	GND	1.994E-16
C336	avC13#17	GND	1.520E-16
C337	CLK#23	GND	1.728E-16
C338	RST#7	GND	1.875E-16
C339	Q0#1	GND	9.433E-17
C340	avI5/avC11#5	GND	5.619E-17
C341	avC13#21	GND	1.572E-16
C342	CLK#26	GND	1.759E-16
C343	avC13#24	GND	1.489E-16
C344	RST#13	GND	1.824E-16
C345	avI6/avC10#5	GND	5.703E-17
C346	CLK#32	GND	1.978E-16
C347	avC13#30	GND	1.519E-16
C348	CLK#36	GND	1.735E-16
C349	Q1#1	GND	9.642E-17
C350	avI6/avC11#5	GND	5.685E-17
C351	RST#21	GND	1.752E-16
C352	avC13#34	GND	1.570E-16
C353	CLK#39	GND	1.748E-16
C354	avC13#37	GND	1.488E-16
C355	RST#25	GND	1.827E-16
C356	avI7/avC10#5	GND	5.703E-17
C357	CLK#45	GND	1.978E-16
C358	avC13#43	GND	1.519E-16
C359	CLK#49	GND	1.735E-16
C360	Q2#1	GND	9.642E-17
C361	avI7/avC11#5	GND	5.685E-17
C362	RST#33	GND	1.752E-16
C363	avC13#47	GND	1.570E-16
C364	CLK#52	GND	1.748E-16
C365	avC13#50	GND	1.488E-16
C366	RST#37	GND	1.827E-16
C367	avI8/avC10#5	GND	5.703E-17
C368	CLK#58	GND	1.978E-16
C369	avC13#56	GND	1.519E-16
C370	CLK#62	GND	1.735E-16
C371	Q3#1	GND	9.642E-17
C372	avI8/avC11#5	GND	5.685E-17
C373	RST#45	GND	1.752E-16
C374	avC13#60	GND	1.570E-16
C375	CLK#65	GND	1.748E-16
C376	avC13#63	GND	1.488E-16
C377	RST#49	GND	1.827E-16
C378	avI9/avC10#5	GND	5.703E-17
C379	CLK#71	GND	1.978E-16
C380	avC13#69	GND	1.519E-16
C381	CLK#75	GND	1.735E-16
C382	Q4#1	GND	9.642E-17
C383	avI9/avC11#5	GND	5.685E-17
C384	RST#57	GND	1.752E-16
C385	avC13#73	GND	1.570E-16
C386	CLK#78	GND	1.748E-16
C387	avC13#76	GND	1.488E-16
C388	RST#61	GND	1.827E-16
C389	avI10/avC10#5	GND	5.703E-17
C390	CLK#84	GND	1.978E-16
C391	avC13#82	GND	1.519E-16
C392	CLK#88	GND	1.735E-16
C393	Q5#1	GND	9.642E-17
C394	avI10/avC11#5	GND	5.685E-17
C395	RST#69	GND	1.752E-16
C396	avC13#86	GND	1.570E-16
C397	CLK#91	GND	1.754E-16
C398	avC13#89	GND	1.504E-16
C399	RST#73	GND	1.824E-16
C400	avI11/avC10#5	GND	5.753E-17
C401	CLK#97	GND	1.983E-16
C402	avC13#95	GND	1.527E-16
C403	CLK#101	GND	1.746E-16
C404	Q6#1	GND	9.586E-17
C405	avI11/avC11#5	GND	5.670E-17
C406	RST#81	GND	1.766E-16
C407	avC13#99	GND	1.577E-16
C408	CLK#104	GND	1.759E-16
C409	avC13#102	GND	1.511E-16
C410	RST#85	GND	1.859E-16
C411	avI12/avC10#5	GND	5.836E-17
C412	CLK#110	GND	1.949E-16
C413	avC13#108	GND	1.521E-16
C414	CLK#114	GND	1.702E-16
C415	Q7#1	GND	9.770E-17
C416	avI12/avC11#5	GND	5.999E-17
C417	RST#93	GND	1.724E-16
C418	Q0#22	GND	1.500E-16
C419	avI2/avC6#3	GND	1.439E-16
C420	Q5#24	GND	1.269E-16
C421	Q0#30	GND	1.807E-16
C422	Q6#22	GND	1.540E-16
C423	avI3/avC6#3	GND	1.448E-16
C424	Q7#16	GND	1.268E-16
C425	Q6#30	GND	1.834E-16
C426	avC16#8	GND	6.843E-17
C427	avI4/avC6#5	GND	1.017E-16
C428	avC15#8	GND	9.832E-17
C429	avC16#15	GND	5.359E-17
C430	avC15#12	GND	1.423E-16
C431	CLK#4	GND	2.987E-16
C432	avC13#7	GND	1.940E-16
C433	avC14#6	GND	6.747E-15
C434	avC13#15	GND	1.125E-15
C435	CLK#17	GND	7.768E-16
C436	RST#12	GND	3.860E-16
C437	Q0#17	GND	2.267E-16
C438	Q0#18	GND	2.216E-15
C439	avC13#28	GND	1.893E-15
C440	CLK#30	GND	1.869E-15
C441	RST#19	GND	7.013E-16
C442	Q1#13	GND	2.020E-16
C443	Q1#19	GND	2.230E-16
C444	avC13#41	GND	1.888E-15
C445	CLK#43	GND	1.879E-15
C446	RST#31	GND	8.870E-16
C447	Q2#13	GND	2.020E-16
C448	Q2#19	GND	2.230E-16
C449	avC13#54	GND	1.888E-15
C450	CLK#56	GND	1.252E-15
C451	RST#43	GND	7.290E-16
C452	Q3#13	GND	2.021E-16
C453	Q3#19	GND	2.230E-16
C454	avC13#67	GND	1.888E-15
C455	CLK#69	GND	1.595E-15
C456	RST#55	GND	5.658E-16
C457	Q4#13	GND	2.020E-16
C458	Q4#19	GND	2.230E-16
C459	avC13#80	GND	1.888E-15
C460	CLK#82	GND	1.879E-15
C461	RST#67	GND	8.870E-16
C462	Q5#13	GND	3.074E-16
C463	Q5#19	GND	1.203E-15
C464	avC13#93	GND	1.888E-15
C465	CLK#95	GND	1.879E-15
C466	RST#79	GND	1.292E-15
C467	Q6#17	GND	2.420E-16
C468	Q6#18	GND	4.804E-16
C469	avC13#106	GND	1.029E-15
C470	CLK#108	GND	9.529E-16
C471	RST#91	GND	6.543E-16
C472	Q7#13	GND	2.700E-16
C473	Q0#28	GND	2.646E-15
C474	avC15#7	GND	5.437E-16
C475	Q5#32	GND	1.122E-15
C476	Q6#26	GND	3.342E-16
C477	avC16#7	GND	2.346E-16
C478	Q7#24	GND	2.344E-16
C479	avC16#14	GND	1.844E-16
C480	avC14#15	GND	7.212E-15
C481	avC15#19	GND	3.994E-16
C482	CLK#3	GND	2.374E-16
C483	avC13#2	GND	6.440E-17
C484	CLK#10	GND	1.789E-16
C485	avC14#4	GND	1.473E-16
C486	avC13#9	GND	1.235E-16
C487	avI5/avC10#2	GND	2.118E-16
C488	avC14#7	GND	6.455E-17
C489	CLK#14	GND	2.176E-16
C490	avI5/avC12#2	GND	7.158E-17
C491	avI5/avC10#4	GND	3.620E-16
C492	avC13#13	GND	5.280E-16
C493	avI5/avC12#4	GND	2.239E-16
C494	avI5/avC9#2	GND	1.818E-16
C495	avI5/avC12#7	GND	2.021E-16
C496	avI5/avC9#4	GND	2.013E-16
C497	avI5/avC10#6	GND	3.980E-16
C498	RST#3	GND	1.734E-16
C499	avI5/avC9#8	GND	2.264E-16
C500	CLK#21	GND	4.054E-16
C501	avI5/avC11#2	GND	2.120E-16
C502	avC13#18	GND	4.674E-16
C503	avI5/avC13#2	GND	1.110E-16
C504	avI5/avC11#4	GND	2.799E-16
C505	CLK#24	GND	2.272E-16
C506	avI5/avC13#4	GND	2.330E-16
C507	RST#8	GND	1.896E-16
C508	Q0#2	GND	1.394E-16
C509	avI5/avC13#6	GND	1.993E-16
C510	Q0#6	GND	1.489E-16
C511	avI5/avC11#6	GND	2.917E-16
C512	Q0#10	GND	1.526E-16
C513	Q0#16	GND	1.256E-16
C514	avC13#22	GND	1.296E-16
C515	avI6/avC10#2	GND	2.121E-16
C516	Q0#20	GND	6.307E-17
C517	CLK#27	GND	2.143E-16
C518	avI6/avC12#2	GND	7.057E-17
C519	avI6/avC10#4	GND	3.583E-16
C520	avC13#26	GND	5.251E-16
C521	avI6/avC12#4	GND	2.231E-16
C522	RST#15	GND	2.253E-16
C523	avI6/avC9#2	GND	1.773E-16
C524	avI6/avC12#6	GND	2.137E-16
C525	avI6/avC9#4	GND	1.942E-16
C526	avI6/avC10#6	GND	3.906E-16
C527	avI6/avC9#8	GND	2.208E-16
C528	CLK#34	GND	4.070E-16
C529	avI6/avC11#2	GND	2.118E-16
C530	avC13#31	GND	4.624E-16
C531	avI6/avC13#2	GND	1.097E-16
C532	avI6/avC11#4	GND	2.771E-16
C533	CLK#37	GND	2.249E-16
C534	avI6/avC13#4	GND	2.345E-16
C535	Q1#2	GND	1.397E-16
C536	avI6/avC13#6	GND	2.093E-16
C537	Q1#6	GND	1.485E-16
C538	avI6/avC11#6	GND	2.884E-16
C539	RST#22	GND	4.804E-16
C540	Q1#10	GND	1.460E-16
C541	Q1#17	GND	1.276E-16
C542	avC13#35	GND	1.293E-16
C543	avI7/avC10#2	GND	2.106E-16
C544	Q1#20	GND	6.740E-17
C545	CLK#40	GND	2.145E-16
C546	avI7/avC12#2	GND	7.364E-17
C547	avI7/avC10#4	GND	3.582E-16
C548	avC13#39	GND	5.251E-16
C549	avI7/avC12#4	GND	2.236E-16
C550	RST#27	GND	2.254E-16
C551	avI7/avC9#2	GND	1.802E-16
C552	avI7/avC12#6	GND	2.137E-16
C553	avI7/avC9#4	GND	1.942E-16
C554	avI7/avC10#6	GND	3.906E-16
C555	avI7/avC9#8	GND	2.208E-16
C556	CLK#47	GND	4.070E-16
C557	avI7/avC11#2	GND	2.118E-16
C558	avC13#44	GND	4.624E-16
C559	avI7/avC13#2	GND	1.097E-16
C560	avI7/avC11#4	GND	2.771E-16
C561	CLK#50	GND	2.249E-16
C562	avI7/avC13#4	GND	2.345E-16
C563	Q2#2	GND	1.397E-16
C564	avI7/avC13#6	GND	2.093E-16
C565	Q2#6	GND	1.485E-16
C566	avI7/avC11#6	GND	2.884E-16
C567	RST#34	GND	4.804E-16
C568	Q2#10	GND	1.460E-16
C569	Q2#17	GND	1.276E-16
C570	avC13#48	GND	1.293E-16
C571	avI8/avC10#2	GND	2.106E-16
C572	Q2#20	GND	6.740E-17
C573	CLK#53	GND	2.145E-16
C574	avI8/avC12#2	GND	7.364E-17
C575	avI8/avC10#4	GND	3.582E-16
C576	avC13#52	GND	5.251E-16
C577	avI8/avC12#4	GND	2.236E-16
C578	RST#39	GND	2.254E-16
C579	avI8/avC9#2	GND	1.802E-16
C580	avI8/avC12#6	GND	2.137E-16
C581	avI8/avC9#4	GND	1.942E-16
C582	avI8/avC10#6	GND	3.906E-16
C583	avI8/avC9#8	GND	2.208E-16
C584	CLK#60	GND	4.069E-16
C585	avI8/avC11#2	GND	2.118E-16
C586	avC13#57	GND	4.623E-16
C587	avI8/avC13#2	GND	1.097E-16
C588	avI8/avC11#4	GND	2.771E-16
C589	CLK#63	GND	2.249E-16
C590	avI8/avC13#4	GND	2.345E-16
C591	Q3#2	GND	1.397E-16
C592	avI8/avC13#6	GND	2.093E-16
C593	Q3#6	GND	1.485E-16
C594	avI8/avC11#6	GND	2.884E-16
C595	RST#46	GND	4.804E-16
C596	Q3#10	GND	1.460E-16
C597	Q3#17	GND	1.276E-16
C598	avC13#61	GND	1.293E-16
C599	avI9/avC10#2	GND	2.106E-16
C600	Q3#20	GND	6.740E-17
C601	CLK#66	GND	2.145E-16
C602	avI9/avC12#2	GND	7.360E-17
C603	avI9/avC10#4	GND	3.582E-16
C604	avC13#65	GND	5.251E-16
C605	avI9/avC12#4	GND	2.236E-16
C606	RST#51	GND	2.254E-16
C607	avI9/avC9#2	GND	1.802E-16
C608	avI9/avC12#6	GND	2.137E-16
C609	avI9/avC9#4	GND	1.942E-16
C610	avI9/avC10#6	GND	3.900E-16
C611	avI9/avC9#8	GND	2.208E-16
C612	CLK#73	GND	4.070E-16
C613	avI9/avC11#2	GND	2.118E-16
C614	avC13#70	GND	4.624E-16
C615	avI9/avC13#2	GND	1.097E-16
C616	avI9/avC11#4	GND	2.771E-16
C617	CLK#76	GND	2.249E-16
C618	avI9/avC13#4	GND	2.345E-16
C619	Q4#2	GND	1.397E-16
C620	avI9/avC13#6	GND	2.093E-16
C621	Q4#6	GND	1.485E-16
C622	avI9/avC11#6	GND	2.884E-16
C623	RST#58	GND	4.804E-16
C624	Q4#10	GND	1.460E-16
C625	Q4#17	GND	1.276E-16
C626	avC13#74	GND	1.293E-16
C627	avI10/avC10#2	GND	2.106E-16
C628	Q4#20	GND	6.740E-17
C629	CLK#79	GND	2.145E-16
C630	avI10/avC12#2	GND	7.364E-17
C631	avI10/avC10#4	GND	3.582E-16
C632	avC13#78	GND	5.251E-16
C633	avI10/avC12#4	GND	2.236E-16
C634	RST#63	GND	2.254E-16
C635	avI10/avC9#2	GND	1.802E-16
C636	avI10/avC12#6	GND	2.137E-16
C637	avI10/avC9#4	GND	1.942E-16
C638	avI10/avC10#6	GND	3.906E-16
C639	avI10/avC9#8	GND	2.208E-16
C640	CLK#86	GND	4.070E-16
C641	avI10/avC11#2	GND	2.118E-16
C642	avC13#83	GND	4.624E-16
C643	avI10/avC13#2	GND	1.097E-16
C644	avI10/avC11#4	GND	2.771E-16
C645	CLK#89	GND	2.249E-16
C646	avI10/avC13#4	GND	2.345E-16
C647	Q5#2	GND	1.397E-16
C648	avI10/avC13#6	GND	2.093E-16
C649	Q5#6	GND	1.485E-16
C650	avI10/avC11#6	GND	2.884E-16
C651	RST#70	GND	4.804E-16
C652	Q5#10	GND	1.460E-16
C653	Q5#17	GND	1.276E-16
C654	avC13#87	GND	1.292E-16
C655	avI11/avC10#2	GND	2.106E-16
C656	Q5#20	GND	6.740E-17
C657	CLK#92	GND	2.145E-16
C658	avI11/avC12#2	GND	7.576E-17
C659	avI11/avC10#4	GND	3.557E-16
C660	avC13#91	GND	5.251E-16
C661	avI11/avC12#4	GND	2.276E-16
C662	RST#75	GND	2.260E-16
C663	avI11/avC9#2	GND	1.811E-16
C664	avI11/avC12#6	GND	2.160E-16
C665	avI11/avC9#4	GND	1.992E-16
C666	avI11/avC10#6	GND	3.900E-16
C667	avI11/avC9#8	GND	2.256E-16
C668	CLK#99	GND	4.070E-16
C669	avI11/avC11#2	GND	2.108E-16
C670	avC13#96	GND	4.618E-16
C671	avI11/avC13#2	GND	1.128E-16
C672	avI11/avC11#4	GND	2.787E-16
C673	CLK#102	GND	2.269E-16
C674	avI11/avC13#4	GND	2.383E-16
C675	Q6#2	GND	1.440E-16
C676	avI11/avC13#6	GND	2.014E-16
C677	Q6#6	GND	1.539E-16
C678	avI11/avC11#6	GND	2.955E-16
C679	RST#82	GND	4.874E-16
C680	Q6#10	GND	1.562E-16
C681	Q6#16	GND	1.279E-16
C682	avC13#100	GND	1.280E-16
C683	avI12/avC10#2	GND	2.121E-16
C684	Q6#20	GND	6.002E-17
C685	CLK#105	GND	2.082E-16
C686	avI12/avC12#2	GND	7.292E-17
C687	avI12/avC10#4	GND	3.622E-16
C688	avC13#104	GND	5.378E-16
C689	avI12/avC12#4	GND	2.274E-16
C690	RST#87	GND	2.259E-16
C691	avI12/avC9#2	GND	1.773E-16
C692	avI12/avC12#6	GND	2.150E-16
C693	avI12/avC9#4	GND	1.974E-16
C694	avI12/avC10#6	GND	3.971E-16
C695	avI12/avC9#8	GND	2.211E-16
C696	CLK#112	GND	4.174E-16
C697	avI12/avC11#2	GND	2.122E-16
C698	avC13#109	GND	4.780E-16
C699	avI12/avC13#2	GND	1.057E-16
C700	avI12/avC11#4	GND	2.837E-16
C701	CLK#115	GND	2.270E-16
C702	avI12/avC13#4	GND	2.353E-16
C703	Q7#2	GND	1.417E-16
C704	avI12/avC13#6	GND	2.141E-16
C705	Q7#6	GND	1.518E-16
C706	avI12/avC11#6	GND	2.834E-16
C707	RST#94	GND	5.127E-16
C708	Q7#10	GND	1.776E-16
C709	avI2/avC6#2	GND	1.706E-16
C710	Q0#24	GND	1.214E-16
C711	Q5#23	GND	1.684E-16
C712	avI2/avC6#4	GND	1.964E-16
C713	avC15#2	GND	1.816E-16
C714	Q0#26	GND	1.278E-16
C715	Q5#25	GND	2.314E-16
C716	avI2/avC6#7	GND	1.428E-16
C717	avC15#5	GND	1.690E-16
C718	Q0#31	GND	1.471E-16
C719	Q5#30	GND	7.597E-17
C720	avI3/avC6#2	GND	1.622E-16
C721	Q6#24	GND	1.304E-16
C722	Q7#15	GND	1.740E-16
C723	avI3/avC6#4	GND	1.974E-16
C724	avC16#2	GND	1.780E-16
C725	Q6#28	GND	1.242E-16
C726	Q7#17	GND	2.399E-16
C727	avI3/avC6#7	GND	1.427E-16
C728	avC16#5	GND	1.725E-16
C729	Q6#31	GND	1.472E-16
C730	Q7#22	GND	1.096E-16
C731	avI4/avC6#2	GND	1.524E-16
C732	avC16#9	GND	1.033E-16
C733	avI4/avC6#4	GND	1.361E-16
C734	avI4/avC6#6	GND	1.390E-16
C735	avC14#10	GND	1.805E-16
C736	avI4/avC7#2	GND	2.833E-16
C737	avC14#13	GND	4.454E-17
C738	avI4/avC10#3	GND	1.985E-16
C739	avC15#9	GND	1.986E-16
C740	avC16#16	GND	3.928E-16
C741	avI4/avC10#5	GND	1.694E-16
C742	avI4/avC7#6	GND	2.179E-16
C743	avC15#14	GND	8.338E-17
C744	avI4/avC7#8	GND	7.921E-17
C745	VDD#2	GND	6.122E-15
C746	VDD#60	GND	4.231E-17
C747	VDD#58	GND	5.389E-17
C748	avC14#8	GND	4.540E-17
C749	avI5/avC10#3	GND	9.768E-17
C750	avI5/avC12#3	GND	1.361E-16
C751	VDD#57	GND	3.727E-17
C752	VDD#56	GND	3.904E-17
C753	avI5/avC9#7	GND	1.635E-16
C754	avI5/avC11#3	GND	1.018E-16
C755	avI5/avC13#3	GND	1.820E-16
C756	VDD#55	GND	3.869E-17
C757	VDD#54	GND	4.119E-17
C758	Q0#9	GND	5.004E-17
C759	Q0#21	GND	4.425E-17
C760	avI6/avC10#3	GND	1.047E-16
C761	avI6/avC12#3	GND	1.460E-16
C762	VDD#53	GND	4.181E-17
C763	VDD#52	GND	4.439E-17
C764	avI6/avC9#7	GND	1.494E-16
C765	avI6/avC11#3	GND	9.704E-17
C766	avI6/avC13#3	GND	1.783E-16
C767	VDD#51	GND	4.017E-17
C768	VDD#50	GND	3.737E-17
C769	Q1#9	GND	6.151E-17
C770	Q1#21	GND	4.915E-17
C771	avI7/avC10#3	GND	1.044E-16
C772	avI7/avC12#3	GND	1.459E-16
C773	VDD#49	GND	4.181E-17
C774	VDD#48	GND	4.439E-17
C775	avI7/avC9#7	GND	1.494E-16
C776	avI7/avC11#3	GND	9.704E-17
C777	avI7/avC13#3	GND	1.783E-16
C778	VDD#47	GND	4.017E-17
C779	VDD#46	GND	3.737E-17
C780	Q2#9	GND	6.151E-17
C781	Q2#21	GND	4.915E-17
C782	avI8/avC10#3	GND	1.044E-16
C783	avI8/avC12#3	GND	1.459E-16
C784	VDD#45	GND	4.181E-17
C785	VDD#44	GND	4.439E-17
C786	avI8/avC9#7	GND	1.494E-16
C787	avI8/avC11#3	GND	9.704E-17
C788	avI8/avC13#3	GND	1.783E-16
C789	VDD#43	GND	4.017E-17
C790	VDD#42	GND	3.737E-17
C791	Q3#9	GND	6.151E-17
C792	Q3#21	GND	4.915E-17
C793	avI9/avC10#3	GND	1.044E-16
C794	avI9/avC12#3	GND	1.459E-16
C795	VDD#41	GND	4.181E-17
C796	VDD#40	GND	4.439E-17
C797	avI9/avC9#7	GND	1.494E-16
C798	avI9/avC11#3	GND	9.704E-17
C799	avI9/avC13#3	GND	1.783E-16
C800	VDD#39	GND	4.017E-17
C801	VDD#38	GND	3.737E-17
C802	Q4#9	GND	6.151E-17
C803	Q4#21	GND	4.915E-17
C804	avI10/avC10#3	GND	1.044E-16
C805	avI10/avC12#3	GND	1.459E-16
C806	VDD#37	GND	4.181E-17
C807	VDD#36	GND	4.439E-17
C808	avI10/avC9#7	GND	1.494E-16
C809	avI10/avC11#3	GND	9.704E-17
C810	avI10/avC13#3	GND	1.783E-16
C811	VDD#35	GND	4.017E-17
C812	VDD#34	GND	3.737E-17
C813	Q5#9	GND	6.151E-17
C814	Q5#21	GND	4.915E-17
C815	avI11/avC10#3	GND	1.044E-16
C816	avI11/avC12#3	GND	1.458E-16
C817	VDD#33	GND	4.181E-17
C818	VDD#32	GND	4.439E-17
C819	avI11/avC9#7	GND	1.487E-16
C820	avI11/avC11#3	GND	9.720E-17
C821	avI11/avC13#3	GND	1.796E-16
C822	VDD#31	GND	4.050E-17
C823	VDD#30	GND	3.235E-17
C824	Q6#9	GND	5.338E-17
C825	Q6#21	GND	4.623E-17
C826	avI12/avC10#3	GND	9.609E-17
C827	avI12/avC12#3	GND	1.387E-16
C828	VDD#29	GND	4.150E-17
C829	VDD#28	GND	4.624E-17
C830	avI12/avC9#7	GND	1.562E-16
C831	avI12/avC11#3	GND	9.462E-17
C832	avI12/avC13#3	GND	1.770E-16
C833	VDD#27	GND	3.237E-17
C834	VDD#26	GND	2.762E-17
C835	Q7#9	GND	7.207E-17
C836	VDD#25	GND	6.979E-17
C837	avC15#3	GND	7.395E-17
C838	Q5#28	GND	7.997E-17
C839	VDD#24	GND	6.626E-17
C840	avC16#3	GND	7.767E-17
C841	Q7#20	GND	8.151E-17
C842	VDD#23	GND	4.716E-17
C843	avC14#9	GND	1.193E-16
C844	avI4/avC10#4	GND	1.038E-18
C845	VDD#22	GND	6.165E-17
C846	avI4/avC10#6	GND	7.398E-19
C847	avI4/avC7#5	GND	1.072E-16
C848	VDD#1	GND	3.265E-17
C849	avC13#3	GND	3.521E-18
C850	avI5/avC12#5	GND	3.453E-17
C851	avI5/avC12#6	GND	4.345E-17
C852	avI5/avC9#3	GND	4.661E-17
C853	avI5/avC9#9	GND	5.906E-17
C854	avI5/avC13#5	GND	2.983E-17
C855	avI5/avC13#8	GND	4.570E-17
C856	Q0#3	GND	2.472E-18
C857	Q0#11	GND	6.047E-17
C858	Q0#13	GND	6.000E-18
C859	avI6/avC12#5	GND	3.915E-17
C860	avI6/avC12#8	GND	4.458E-17
C861	avI6/avC9#3	GND	4.856E-17
C862	avI6/avC9#9	GND	5.934E-17
C863	avI6/avC13#5	GND	2.793E-17
C864	avI6/avC13#8	GND	4.461E-17
C865	Q1#3	GND	3.118E-18
C866	Q1#11	GND	6.210E-17
C867	Q1#14	GND	6.278E-18
C868	avI7/avC12#5	GND	3.915E-17
C869	avI7/avC12#8	GND	4.458E-17
C870	avI7/avC9#3	GND	4.856E-17
C871	avI7/avC9#9	GND	5.934E-17
C872	avI7/avC13#5	GND	2.793E-17
C873	avI7/avC13#8	GND	4.461E-17
C874	Q2#3	GND	3.118E-18
C875	Q2#11	GND	6.210E-17
C876	Q2#14	GND	6.278E-18
C877	avI8/avC12#5	GND	3.915E-17
C878	avI8/avC12#8	GND	4.458E-17
C879	avI8/avC9#3	GND	4.856E-17
C880	avI8/avC9#9	GND	5.934E-17
C881	avI8/avC13#5	GND	2.793E-17
C882	avI8/avC13#8	GND	4.461E-17
C883	Q3#3	GND	3.118E-18
C884	Q3#11	GND	6.210E-17
C885	Q3#14	GND	6.278E-18
C886	avI9/avC12#5	GND	3.915E-17
C887	avI9/avC12#8	GND	4.458E-17
C888	avI9/avC9#3	GND	4.856E-17
C889	avI9/avC9#9	GND	5.934E-17
C890	avI9/avC13#5	GND	2.793E-17
C891	avI9/avC13#8	GND	4.461E-17
C892	Q4#3	GND	3.118E-18
C893	Q4#11	GND	6.210E-17
C894	Q4#14	GND	6.278E-18
C895	avI10/avC12#5	GND	3.915E-17
C896	avI10/avC12#8	GND	4.458E-17
C897	avI10/avC9#3	GND	4.856E-17
C898	avI10/avC9#9	GND	5.934E-17
C899	avI10/avC13#5	GND	2.793E-17
C900	avI10/avC13#8	GND	4.461E-17
C901	Q5#3	GND	3.118E-18
C902	Q5#11	GND	6.210E-17
C903	Q5#14	GND	6.278E-18
C904	avI11/avC12#5	GND	3.915E-17
C905	avI11/avC12#8	GND	4.460E-17
C906	avI11/avC9#3	GND	5.126E-17
C907	avI11/avC9#9	GND	6.162E-17
C908	avI11/avC13#5	GND	2.685E-17
C909	avI11/avC13#8	GND	4.570E-17
C910	Q6#3	GND	3.390E-18
C911	Q6#11	GND	6.218E-17
C912	Q6#13	GND	6.538E-18
C913	avI12/avC12#5	GND	3.915E-17
C914	avI12/avC12#8	GND	4.458E-17
C915	avI12/avC9#3	GND	4.334E-17
C916	avI12/avC9#9	GND	5.279E-17
C917	avI12/avC13#5	GND	2.584E-17
C918	avI12/avC13#8	GND	4.313E-17
C919	Q7#11	GND	6.568E-17
C920	Q5#22	GND	8.732E-17
C921	avI2/avC6#6	GND	4.889E-17
C922	Q7#14	GND	6.887E-17
C923	avI3/avC6#6	GND	4.923E-17
C924	avI4/avC6#3	GND	4.190E-17
C925	avC14#11	GND	7.819E-17
C926	avI4/avC7#7	GND	3.459E-17
C927	Q5#29	GND	8.839E-17
C928	Q7#21	GND	9.040E-17
C929	avC13#4	GND	1.913E-16
C930	avC14#2	GND	1.408E-16
C931	Q0#4	GND	5.016E-17
C932	Q0#14	GND	1.193E-16
C933	Q1#4	GND	5.019E-17
C934	Q1#15	GND	1.164E-16
C935	Q2#4	GND	5.019E-17
C936	Q2#15	GND	1.164E-16
C937	Q3#4	GND	5.021E-17
C938	Q3#15	GND	1.164E-16
C939	Q4#4	GND	5.019E-17
C940	Q4#15	GND	1.164E-16
C941	Q5#4	GND	5.019E-17
C942	Q5#15	GND	1.164E-16
C943	Q6#4	GND	5.150E-17
C944	Q6#14	GND	1.201E-16
C945	Q7#4	GND	4.674E-17
*
*
.ENDS MS_LFSR_8bit
*
