// MUX2_N - cong phu tro cua TV4 (gpdk090, 1.2 V), dung cell TV3 (INV_X1, NAND2_X1).
simulator lang=spectre
// MUX2: Y = S ? B : A   (3 NAND2, SB tu ngoai dua vao de dung chung) - 12 transistor
subckt MUX2_N A B S SB Y VDD GND
    I0 (A SB na VDD GND) NAND2_X1
    I1 (B S nb VDD GND) NAND2_X1
    I2 (na nb Y VDD GND) NAND2_X1
ends MUX2_N
