// tb_TSPC_LFSR_post, corner SS
simulator lang=spectre
include "/home/buet/cadence/gpdk090_v4.6/models/spectre/gpdk090.scs" section=SS
include "../depend/tv3/cells/cells.scs"
include "../cells/cells.scs"
include "../layout/rcx/TSPC_LFSR_8bit_post.scs"
include "tb_TSPC_LFSR_post.scs"
