// cells.scs - flip-flop MS cua TV1 (ban sao, xem ../NGUON.md). Include sau file model.
simulator lang=spectre
include "MS_DFF_SetReset/MS_DFF_SetReset.scs"
