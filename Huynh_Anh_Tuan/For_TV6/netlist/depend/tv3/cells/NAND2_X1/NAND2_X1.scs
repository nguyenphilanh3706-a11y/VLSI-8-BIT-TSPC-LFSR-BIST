// NAND2_X1 (ALU_CELLS_A).  Y = !(A & B)
// Pins: A B Y VDD GND
simulator lang=spectre
subckt NAND2_X1 A B Y VDD GND
    MN0 (Y A n1 GND) gpdk090_nmos1v w=0.24u l=0.1u
    MN1 (n1 B GND GND) gpdk090_nmos1v w=0.24u l=0.1u
    MP0 (Y A VDD VDD) gpdk090_pmos1v w=0.24u l=0.1u
    MP1 (Y B VDD VDD) gpdk090_pmos1v w=0.24u l=0.1u
ends NAND2_X1
