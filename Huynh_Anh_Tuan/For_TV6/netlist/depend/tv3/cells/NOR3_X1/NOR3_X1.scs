// NOR3_X1.  Y = !(A | B | C)
// Pins: A B C Y VDD GND
simulator lang=spectre
subckt NOR3_X1 A B C Y VDD GND
    MN0 (Y A GND GND) gpdk090_nmos1v w=0.12u l=0.1u
    MN1 (Y B GND GND) gpdk090_nmos1v w=0.12u l=0.1u
    MN2 (Y C GND GND) gpdk090_nmos1v w=0.12u l=0.1u
    MP0 (p1 A VDD VDD) gpdk090_pmos1v w=0.48u l=0.1u
    MP1 (p2 B p1 VDD) gpdk090_pmos1v w=0.48u l=0.1u
    MP2 (Y C p2 VDD) gpdk090_pmos1v w=0.48u l=0.1u
ends NOR3_X1
