// TSPC_LFSR_8bit sau layout: Assura RCX (R + C), sinh boi scripts/layout/rcx2scs.py
simulator lang=spice
.SUBCKT TSPC_LFSR_8bit_RCX VDD GND CLK Q0 Q1 Q2 Q3 Q4 Q5 Q6 Q7 RST
MavI11/avD1_1	GND_h103	Q6_h17	avI11/avC8_h3	GND_h2 gpdk090_nmos1v	L=0.1U
+ W=0.24U
+ AD=0.0696P	AS=0.0984P	PD=0.82U	PS=1.3U
MavI11/avD1_2	avI11/avC9_h7	RST_h63	GND_h103	GND_h2 gpdk090_nmos1v	L=0.1U
+ W=0.24U
+ AD=0.0984P	AS=0.0696P	PD=1.3U	PS=0.82U
MavI11/avD1_3	avI11/avC10	avI11/avC8_h7	avI11/avC9_h5	GND_h2 gpdk090_nmos1v
+ L=0.1U	W=0.48U
+ AD=0.1392P	AS=0.1968P	PD=1.06U	PS=1.78U
MavI11/avD1_4	GND_h102	CLK_h114	avI11/avC10	GND_h2 gpdk090_nmos1v
+ L=0.1U	W=0.48U
+ AD=0.1968P	AS=0.1392P	PD=1.78U	PS=1.06U
MavI11/avD1_5	avI11/avC11	avI11/avC9_h11	GND_h101	GND_h2 gpdk090_nmos1v
+ L=0.1U	W=0.24U
+ AD=0.0696P	AS=0.0984P	PD=0.82U	PS=1.3U
MavI11/avD1_6	avC1_11_h9	CLK_h119	avI11/avC11	GND_h2 gpdk090_nmos1v
+ L=0.1U	W=0.24U
+ AD=0.0984P	AS=0.0696P	PD=1.3U	PS=0.82U
MavI11/avD1_7	Q7_h7	avC1_11_h14	GND_h100	GND_h2 gpdk090_nmos1v	L=0.1U
+ W=0.24U
+ AD=0.0984P	AS=0.0984P	PD=1.3U	PS=1.3U
MavI10/avD1_1	GND_h107	Q5_h17	avI10/avC8_h3	GND_h2 gpdk090_nmos1v	L=0.1U
+ W=0.24U
+ AD=0.0696P	AS=0.0984P	PD=0.82U	PS=1.3U
MavI10/avD1_2	avI10/avC9_h7	RST_h55	GND_h107	GND_h2 gpdk090_nmos1v	L=0.1U
+ W=0.24U
+ AD=0.0984P	AS=0.0696P	PD=1.3U	PS=0.82U
MavI10/avD1_3	avI10/avC10	avI10/avC8_h7	avI10/avC9_h5	GND_h2 gpdk090_nmos1v
+ L=0.1U	W=0.48U
+ AD=0.1392P	AS=0.1968P	PD=1.06U	PS=1.78U
MavI10/avD1_4	GND_h106	CLK_h99	avI10/avC10	GND_h2 gpdk090_nmos1v	L=0.1U
+ W=0.48U
+ AD=0.1968P	AS=0.1392P	PD=1.78U	PS=1.06U
MavI10/avD1_5	avI10/avC11	avI10/avC9_h11	GND_h105	GND_h2 gpdk090_nmos1v
+ L=0.1U	W=0.24U
+ AD=0.0696P	AS=0.0984P	PD=0.82U	PS=1.3U
MavI10/avD1_6	avC1_10_h9	CLK_h103	avI10/avC11	GND_h2 gpdk090_nmos1v
+ L=0.1U	W=0.24U
+ AD=0.0984P	AS=0.0696P	PD=1.3U	PS=0.82U
MavI10/avD1_7	Q6_h7	avC1_10_h14	GND_h104	GND_h2 gpdk090_nmos1v	L=0.1U
+ W=0.24U
+ AD=0.0984P	AS=0.0984P	PD=1.3U	PS=1.3U
MavI9/avD1_1	GND_h111	Q4_h17	avI9/avC8_h3	GND_h2 gpdk090_nmos1v	L=0.1U
+ W=0.24U
+ AD=0.0696P	AS=0.0984P	PD=0.82U	PS=1.3U
MavI9/avD1_2	avI9/avC9_h7	RST_h47	GND_h111	GND_h2 gpdk090_nmos1v	L=0.1U
+ W=0.24U
+ AD=0.0984P	AS=0.0696P	PD=1.3U	PS=0.82U
MavI9/avD1_3	avI9/avC10	avI9/avC8_h7	avI9/avC9_h5	GND_h2 gpdk090_nmos1v
+ L=0.1U	W=0.48U
+ AD=0.1392P	AS=0.1968P	PD=1.06U	PS=1.78U
MavI9/avD1_4	GND_h110	CLK_h84	avI9/avC10	GND_h2 gpdk090_nmos1v	L=0.1U
+ W=0.48U
+ AD=0.1968P	AS=0.1392P	PD=1.78U	PS=1.06U
MavI9/avD1_5	avI9/avC11	avI9/avC9_h11	GND_h109	GND_h2 gpdk090_nmos1v
+ L=0.1U	W=0.24U
+ AD=0.0696P	AS=0.0984P	PD=0.82U	PS=1.3U
MavI9/avD1_6	avC1_9_h9	CLK_h88	avI9/avC11	GND_h2 gpdk090_nmos1v	L=0.1U
+ W=0.24U
+ AD=0.0984P	AS=0.0696P	PD=1.3U	PS=0.82U
MavI9/avD1_7	Q5_h7	avC1_9_h14	GND_h108	GND_h2 gpdk090_nmos1v	L=0.1U
+ W=0.24U
+ AD=0.0984P	AS=0.0984P	PD=1.3U	PS=1.3U
MavI8/avD1_1	GND_h115	Q3_h17	avI8/avC8_h3	GND_h2 gpdk090_nmos1v	L=0.1U
+ W=0.24U
+ AD=0.0696P	AS=0.0984P	PD=0.82U	PS=1.3U
MavI8/avD1_2	avI8/avC9_h7	RST_h39	GND_h115	GND_h2 gpdk090_nmos1v	L=0.1U
+ W=0.24U
+ AD=0.0984P	AS=0.0696P	PD=1.3U	PS=0.82U
MavI8/avD1_3	avI8/avC10	avI8/avC8_h7	avI8/avC9_h5	GND_h2 gpdk090_nmos1v
+ L=0.1U	W=0.48U
+ AD=0.1392P	AS=0.1968P	PD=1.06U	PS=1.78U
MavI8/avD1_4	GND_h114	CLK_h69	avI8/avC10	GND_h2 gpdk090_nmos1v	L=0.1U
+ W=0.48U
+ AD=0.1968P	AS=0.1392P	PD=1.78U	PS=1.06U
MavI8/avD1_5	avI8/avC11	avI8/avC9_h11	GND_h113	GND_h2 gpdk090_nmos1v
+ L=0.1U	W=0.24U
+ AD=0.0696P	AS=0.0984P	PD=0.82U	PS=1.3U
MavI8/avD1_6	avC1_8_h9	CLK_h73	avI8/avC11	GND_h2 gpdk090_nmos1v	L=0.1U
+ W=0.24U
+ AD=0.0984P	AS=0.0696P	PD=1.3U	PS=0.82U
MavI8/avD1_7	Q4_h7	avC1_8_h14	GND_h112	GND_h2 gpdk090_nmos1v	L=0.1U
+ W=0.24U
+ AD=0.0984P	AS=0.0984P	PD=1.3U	PS=1.3U
MavI7/avD1_1	GND_h119	Q2_h17	avI7/avC8_h3	GND_h2 gpdk090_nmos1v	L=0.1U
+ W=0.24U
+ AD=0.0696P	AS=0.0984P	PD=0.82U	PS=1.3U
MavI7/avD1_2	avI7/avC9_h7	RST_h31	GND_h119	GND_h2 gpdk090_nmos1v	L=0.1U
+ W=0.24U
+ AD=0.0984P	AS=0.0696P	PD=1.3U	PS=0.82U
MavI7/avD1_3	avI7/avC10	avI7/avC8_h7	avI7/avC9_h5	GND_h2 gpdk090_nmos1v
+ L=0.1U	W=0.48U
+ AD=0.1392P	AS=0.1968P	PD=1.06U	PS=1.78U
MavI7/avD1_4	GND_h118	CLK_h54	avI7/avC10	GND_h2 gpdk090_nmos1v	L=0.1U
+ W=0.48U
+ AD=0.1968P	AS=0.1392P	PD=1.78U	PS=1.06U
MavI7/avD1_5	avI7/avC11	avI7/avC9_h11	GND_h117	GND_h2 gpdk090_nmos1v
+ L=0.1U	W=0.24U
+ AD=0.0696P	AS=0.0984P	PD=0.82U	PS=1.3U
MavI7/avD1_6	avC1_7_h9	CLK_h58	avI7/avC11	GND_h2 gpdk090_nmos1v	L=0.1U
+ W=0.24U
+ AD=0.0984P	AS=0.0696P	PD=1.3U	PS=0.82U
MavI7/avD1_7	Q3_h7	avC1_7_h14	GND_h116	GND_h2 gpdk090_nmos1v	L=0.1U
+ W=0.24U
+ AD=0.0984P	AS=0.0984P	PD=1.3U	PS=1.3U
MavI6/avD1_1	GND_h123	Q1_h17	avI6/avC8_h3	GND_h2 gpdk090_nmos1v	L=0.1U
+ W=0.24U
+ AD=0.0696P	AS=0.0984P	PD=0.82U	PS=1.3U
MavI6/avD1_2	avI6/avC9_h7	RST_h23	GND_h123	GND_h2 gpdk090_nmos1v	L=0.1U
+ W=0.24U
+ AD=0.0984P	AS=0.0696P	PD=1.3U	PS=0.82U
MavI6/avD1_3	avI6/avC10	avI6/avC8_h7	avI6/avC9_h5	GND_h2 gpdk090_nmos1v
+ L=0.1U	W=0.48U
+ AD=0.1392P	AS=0.1968P	PD=1.06U	PS=1.78U
MavI6/avD1_4	GND_h122	CLK_h39	avI6/avC10	GND_h2 gpdk090_nmos1v	L=0.1U
+ W=0.48U
+ AD=0.1968P	AS=0.1392P	PD=1.78U	PS=1.06U
MavI6/avD1_5	avI6/avC11	avI6/avC9_h11	GND_h121	GND_h2 gpdk090_nmos1v
+ L=0.1U	W=0.24U
+ AD=0.0696P	AS=0.0984P	PD=0.82U	PS=1.3U
MavI6/avD1_6	avC1_6_h9	CLK_h43	avI6/avC11	GND_h2 gpdk090_nmos1v	L=0.1U
+ W=0.24U
+ AD=0.0984P	AS=0.0696P	PD=1.3U	PS=0.82U
MavI6/avD1_7	Q2_h7	avC1_6_h14	GND_h120	GND_h2 gpdk090_nmos1v	L=0.1U
+ W=0.24U
+ AD=0.0984P	AS=0.0984P	PD=1.3U	PS=1.3U
MavI5/avD1_1	GND_h127	Q0_h17	avI5/avC8_h3	GND_h2 gpdk090_nmos1v	L=0.1U
+ W=0.24U
+ AD=0.0696P	AS=0.0984P	PD=0.82U	PS=1.3U
MavI5/avD1_2	avI5/avC9_h7	RST_h15	GND_h127	GND_h2 gpdk090_nmos1v	L=0.1U
+ W=0.24U
+ AD=0.0984P	AS=0.0696P	PD=1.3U	PS=0.82U
MavI5/avD1_3	avI5/avC10	avI5/avC8_h7	avI5/avC9_h5	GND_h2 gpdk090_nmos1v
+ L=0.1U	W=0.48U
+ AD=0.1392P	AS=0.1968P	PD=1.06U	PS=1.78U
MavI5/avD1_4	GND_h126	CLK_h24	avI5/avC10	GND_h2 gpdk090_nmos1v	L=0.1U
+ W=0.48U
+ AD=0.1968P	AS=0.1392P	PD=1.78U	PS=1.06U
MavI5/avD1_5	avI5/avC11	avI5/avC9_h11	GND_h125	GND_h2 gpdk090_nmos1v
+ L=0.1U	W=0.24U
+ AD=0.0696P	AS=0.0984P	PD=0.82U	PS=1.3U
MavI5/avD1_6	avC1_5_h9	CLK_h28	avI5/avC11	GND_h2 gpdk090_nmos1v	L=0.1U
+ W=0.24U
+ AD=0.0984P	AS=0.0696P	PD=1.3U	PS=0.82U
MavI5/avD1_7	Q1_h7	avC1_5_h14	GND_h124	GND_h2 gpdk090_nmos1v	L=0.1U
+ W=0.24U
+ AD=0.0984P	AS=0.0984P	PD=1.3U	PS=1.3U
MavI4/avD1_1	avI4/avC6_h3	avC15_h12	GND_h97	GND_h2 gpdk090_nmos1v	L=0.1U
+ W=0.12U
+ AD=0.0696P	AS=0.0696P	PD=1.16U	PS=1.16U
MavI4/avD1_2	avI4/avC8	avI4/avC6_h8	GND_h96	GND_h2 gpdk090_nmos1v	L=0.1U
+ W=0.24U
+ AD=0.0528P	AS=0.0816P	PD=0.68U	PS=1.16U
MavI4/avD1_3	avC13_h11	avI4/avC7_h4	avI4/avC8	GND_h2 gpdk090_nmos1v
+ L=0.1U	W=0.24U
+ AD=0.0528P	AS=0.0528P	PD=0.68U	PS=0.68U
MavI4/avD1_4	avI4/avC9	avC14_h11	avC13_h11	GND_h2 gpdk090_nmos1v
+ L=0.1U	W=0.24U
+ AD=0.0528P	AS=0.0528P	PD=0.68U	PS=0.68U
MavI4/avD1_5	GND_h95	avC15_h18	avI4/avC9	GND_h2 gpdk090_nmos1v	L=0.1U
+ W=0.24U
+ AD=0.0816P	AS=0.0528P	PD=1.16U	PS=0.68U
MavI4/avD1_6	avI4/avC7_h7	avC14_h18	GND_h1	GND_h2 gpdk090_nmos1v	L=0.1U
+ W=0.12U
+ AD=0.0696P	AS=0.0696P	PD=1.16U	PS=1.16U
MavI3/avD1_1	avC15	avI3/avC6_h5	Q7_h10	GND_h2 gpdk090_nmos1v	L=0.1U	W=0.12U
+ AD=0.0468P	AS=0.1992P	PD=0.68U	PS=2.24U
MavI3/avD1_2	avI3/avC6_h6	Q7_h15	avC15	GND_h2 gpdk090_nmos1v	L=0.1U	W=0.24U
+ AD=0.0468P	AS=0.0468P	PD=0.68U	PS=0.68U
MavI3/avD1_3	GND_h98	Q6_h29	avI3/avC6_h6	GND_h2 gpdk090_nmos1v	L=0.1U	W=0.12U
+ AD=0.0696P	AS=0.0468P	PD=1.16U	PS=0.68U
MavI2/avD1_1	avC14	avI2/avC6_h5	Q5_h18	GND_h2 gpdk090_nmos1v	L=0.1U	W=0.12U
+ AD=0.0468P	AS=0.1992P	PD=0.68U	PS=2.24U
MavI2/avD1_2	avI2/avC6_h6	Q5_h23	avC14	GND_h2 gpdk090_nmos1v	L=0.1U	W=0.24U
+ AD=0.0468P	AS=0.0468P	PD=0.68U	PS=0.68U
MavI2/avD1_3	GND_h99	Q0_h29	avI2/avC6_h6	GND_h2 gpdk090_nmos1v	L=0.1U	W=0.12U
+ AD=0.0696P	AS=0.0468P	PD=1.16U	PS=0.68U
MavI1/avD1_1	GND_h135	avC13_h7	avI1/avC8_h3	GND_h2 gpdk090_nmos1v
+ L=0.1U	W=0.24U
+ AD=0.1188P	AS=0.0984P	PD=1.06U	PS=1.3U
MavI1/avD1_2	avI1/avC10	CLK_h9	GND_h135	GND_h2 gpdk090_nmos1v	L=0.1U
+ W=0.48U
+ AD=0.1392P	AS=0.1188P	PD=1.06U	PS=1.06U
MavI1/avD1_3	avI1/avC9	avI1/avC8_h7	avI1/avC10	GND_h2 gpdk090_nmos1v
+ L=0.1U	W=0.48U
+ AD=0.1968P	AS=0.1392P	PD=1.78U	PS=1.06U
MavI1/avD1_4	GND_h136	RST_h7	avC1_1_h3	GND_h2 gpdk090_nmos1v	L=0.1U
+ W=0.24U
+ AD=0.0696P	AS=0.0984P	PD=0.82U	PS=1.3U
MavI1/avD1_5	avI1/avC11	avI1/avC9_h9	GND_h136	GND_h2 gpdk090_nmos1v
+ L=0.1U	W=0.24U
+ AD=0.0696P	AS=0.0696P	PD=0.82U	PS=0.82U
MavI1/avD1_6	avC1_1_h11	CLK_h14	avI1/avC11	GND_h2 gpdk090_nmos1v	L=0.1U
+ W=0.24U
+ AD=0.0984P	AS=0.0696P	PD=1.3U	PS=0.82U
MavI1/avD1_7	Q0_h7	avC1_1_h16	GND_h128	GND_h2 gpdk090_nmos1v	L=0.1U
+ W=0.24U
+ AD=0.0984P	AS=0.0984P	PD=1.3U	PS=1.3U
MavI11/avD7_1	avI11/avC12	CLK_h107	avI11/avC8	VDD_h2 gpdk090_pmos1v
+ L=0.1U	W=0.48U
+ AD=0.1392P	AS=0.1968P	PD=1.06U	PS=1.78U
MavI11/avD7_2	VDD_h102	Q6_h15	avI11/avC12	VDD_h2 gpdk090_pmos1v	L=0.1U
+ W=0.48U
+ AD=0.1392P	AS=0.1392P	PD=1.06U	PS=1.06U
MavI11/avD7_3	avI11/avC13	RST_h61	VDD_h102	VDD_h2 gpdk090_pmos1v	L=0.1U
+ W=0.48U
+ AD=0.1392P	AS=0.1392P	PD=1.06U	PS=1.06U
MavI11/avD7_4	avI11/avC9_h2	CLK_h110	avI11/avC13	VDD_h2 gpdk090_pmos1v
+ L=0.1U	W=0.48U
+ AD=0.1968P	AS=0.1392P	PD=1.78U	PS=1.06U
MavI11/avD7_5	VDD_h101	avC1_11_h3	avI11/avC9	VDD_h2 gpdk090_pmos1v
+ L=0.4U	W=0.12U
+ AD=0.1086P	AS=0.078P	PD=1.06U	PS=1.3U
MavI11/avD7_6	avC1_11_h8	avI11/avC9_h10	VDD_h101	VDD_h2 gpdk090_pmos1v
+ L=0.1U	W=0.48U
+ AD=0.1968P	AS=0.1086P	PD=1.78U	PS=1.06U
MavI11/avD7_7	VDD_h100	Q7_h3	avC1_11_h6	VDD_h2 gpdk090_pmos1v	L=0.4U
+ W=0.12U
+ AD=0.1086P	AS=0.078P	PD=1.06U	PS=1.3U
MavI11/avD7_8	Q7_h4	avC1_11_h13	VDD_h100	VDD_h2 gpdk090_pmos1v	L=0.1U
+ W=0.48U
+ AD=0.1968P	AS=0.1086P	PD=1.78U	PS=1.06U
MavI10/avD7_1	avI10/avC12	CLK_h92	avI10/avC8	VDD_h2 gpdk090_pmos1v	L=0.1U
+ W=0.48U
+ AD=0.1392P	AS=0.1968P	PD=1.06U	PS=1.78U
MavI10/avD7_2	VDD_h105	Q5_h15	avI10/avC12	VDD_h2 gpdk090_pmos1v	L=0.1U
+ W=0.48U
+ AD=0.1392P	AS=0.1392P	PD=1.06U	PS=1.06U
MavI10/avD7_3	avI10/avC13	RST_h53	VDD_h105	VDD_h2 gpdk090_pmos1v	L=0.1U
+ W=0.48U
+ AD=0.1392P	AS=0.1392P	PD=1.06U	PS=1.06U
MavI10/avD7_4	avI10/avC9_h2	CLK_h95	avI10/avC13	VDD_h2 gpdk090_pmos1v	L=0.1U
+ W=0.48U
+ AD=0.1968P	AS=0.1392P	PD=1.78U	PS=1.06U
MavI10/avD7_5	VDD_h104	avC1_10_h3	avI10/avC9	VDD_h2 gpdk090_pmos1v
+ L=0.4U	W=0.12U
+ AD=0.1086P	AS=0.078P	PD=1.06U	PS=1.3U
MavI10/avD7_6	avC1_10_h8	avI10/avC9_h10	VDD_h104	VDD_h2 gpdk090_pmos1v
+ L=0.1U	W=0.48U
+ AD=0.1968P	AS=0.1086P	PD=1.78U	PS=1.06U
MavI10/avD7_7	VDD_h103	Q6_h3	avC1_10_h6	VDD_h2 gpdk090_pmos1v	L=0.4U
+ W=0.12U
+ AD=0.1086P	AS=0.078P	PD=1.06U	PS=1.3U
MavI10/avD7_8	Q6_h4	avC1_10_h13	VDD_h103	VDD_h2 gpdk090_pmos1v	L=0.1U
+ W=0.48U
+ AD=0.1968P	AS=0.1086P	PD=1.78U	PS=1.06U
MavI9/avD7_1	avI9/avC12	CLK_h77	avI9/avC8	VDD_h2 gpdk090_pmos1v	L=0.1U
+ W=0.48U
+ AD=0.1392P	AS=0.1968P	PD=1.06U	PS=1.78U
MavI9/avD7_2	VDD_h108	Q4_h15	avI9/avC12	VDD_h2 gpdk090_pmos1v	L=0.1U
+ W=0.48U
+ AD=0.1392P	AS=0.1392P	PD=1.06U	PS=1.06U
MavI9/avD7_3	avI9/avC13	RST_h45	VDD_h108	VDD_h2 gpdk090_pmos1v	L=0.1U
+ W=0.48U
+ AD=0.1392P	AS=0.1392P	PD=1.06U	PS=1.06U
MavI9/avD7_4	avI9/avC9_h2	CLK_h80	avI9/avC13	VDD_h2 gpdk090_pmos1v	L=0.1U
+ W=0.48U
+ AD=0.1968P	AS=0.1392P	PD=1.78U	PS=1.06U
MavI9/avD7_5	VDD_h107	avC1_9_h3	avI9/avC9	VDD_h2 gpdk090_pmos1v
+ L=0.4U	W=0.12U
+ AD=0.1086P	AS=0.078P	PD=1.06U	PS=1.3U
MavI9/avD7_6	avC1_9_h8	avI9/avC9_h10	VDD_h107	VDD_h2 gpdk090_pmos1v
+ L=0.1U	W=0.48U
+ AD=0.1968P	AS=0.1086P	PD=1.78U	PS=1.06U
MavI9/avD7_7	VDD_h106	Q5_h3	avC1_9_h6	VDD_h2 gpdk090_pmos1v	L=0.4U
+ W=0.12U
+ AD=0.1086P	AS=0.078P	PD=1.06U	PS=1.3U
MavI9/avD7_8	Q5_h4	avC1_9_h13	VDD_h106	VDD_h2 gpdk090_pmos1v	L=0.1U
+ W=0.48U
+ AD=0.1968P	AS=0.1086P	PD=1.78U	PS=1.06U
MavI8/avD7_1	avI8/avC12	CLK_h62	avI8/avC8	VDD_h2 gpdk090_pmos1v	L=0.1U
+ W=0.48U
+ AD=0.1392P	AS=0.1968P	PD=1.06U	PS=1.78U
MavI8/avD7_2	VDD_h111	Q3_h15	avI8/avC12	VDD_h2 gpdk090_pmos1v	L=0.1U
+ W=0.48U
+ AD=0.1392P	AS=0.1392P	PD=1.06U	PS=1.06U
MavI8/avD7_3	avI8/avC13	RST_h37	VDD_h111	VDD_h2 gpdk090_pmos1v	L=0.1U
+ W=0.48U
+ AD=0.1392P	AS=0.1392P	PD=1.06U	PS=1.06U
MavI8/avD7_4	avI8/avC9_h2	CLK_h65	avI8/avC13	VDD_h2 gpdk090_pmos1v	L=0.1U
+ W=0.48U
+ AD=0.1968P	AS=0.1392P	PD=1.78U	PS=1.06U
MavI8/avD7_5	VDD_h110	avC1_8_h3	avI8/avC9	VDD_h2 gpdk090_pmos1v
+ L=0.4U	W=0.12U
+ AD=0.1086P	AS=0.078P	PD=1.06U	PS=1.3U
MavI8/avD7_6	avC1_8_h8	avI8/avC9_h10	VDD_h110	VDD_h2 gpdk090_pmos1v
+ L=0.1U	W=0.48U
+ AD=0.1968P	AS=0.1086P	PD=1.78U	PS=1.06U
MavI8/avD7_7	VDD_h109	Q4_h3	avC1_8_h6	VDD_h2 gpdk090_pmos1v	L=0.4U
+ W=0.12U
+ AD=0.1086P	AS=0.078P	PD=1.06U	PS=1.3U
MavI8/avD7_8	Q4_h4	avC1_8_h13	VDD_h109	VDD_h2 gpdk090_pmos1v	L=0.1U
+ W=0.48U
+ AD=0.1968P	AS=0.1086P	PD=1.78U	PS=1.06U
MavI7/avD7_1	avI7/avC12	CLK_h47	avI7/avC8	VDD_h2 gpdk090_pmos1v	L=0.1U
+ W=0.48U
+ AD=0.1392P	AS=0.1968P	PD=1.06U	PS=1.78U
MavI7/avD7_2	VDD_h114	Q2_h15	avI7/avC12	VDD_h2 gpdk090_pmos1v	L=0.1U
+ W=0.48U
+ AD=0.1392P	AS=0.1392P	PD=1.06U	PS=1.06U
MavI7/avD7_3	avI7/avC13	RST_h29	VDD_h114	VDD_h2 gpdk090_pmos1v	L=0.1U
+ W=0.48U
+ AD=0.1392P	AS=0.1392P	PD=1.06U	PS=1.06U
MavI7/avD7_4	avI7/avC9_h2	CLK_h50	avI7/avC13	VDD_h2 gpdk090_pmos1v	L=0.1U
+ W=0.48U
+ AD=0.1968P	AS=0.1392P	PD=1.78U	PS=1.06U
MavI7/avD7_5	VDD_h113	avC1_7_h3	avI7/avC9	VDD_h2 gpdk090_pmos1v
+ L=0.4U	W=0.12U
+ AD=0.1086P	AS=0.078P	PD=1.06U	PS=1.3U
MavI7/avD7_6	avC1_7_h8	avI7/avC9_h10	VDD_h113	VDD_h2 gpdk090_pmos1v
+ L=0.1U	W=0.48U
+ AD=0.1968P	AS=0.1086P	PD=1.78U	PS=1.06U
MavI7/avD7_7	VDD_h112	Q3_h3	avC1_7_h6	VDD_h2 gpdk090_pmos1v	L=0.4U
+ W=0.12U
+ AD=0.1086P	AS=0.078P	PD=1.06U	PS=1.3U
MavI7/avD7_8	Q3_h4	avC1_7_h13	VDD_h112	VDD_h2 gpdk090_pmos1v	L=0.1U
+ W=0.48U
+ AD=0.1968P	AS=0.1086P	PD=1.78U	PS=1.06U
MavI6/avD7_1	avI6/avC12	CLK_h32	avI6/avC8	VDD_h2 gpdk090_pmos1v	L=0.1U
+ W=0.48U
+ AD=0.1392P	AS=0.1968P	PD=1.06U	PS=1.78U
MavI6/avD7_2	VDD_h117	Q1_h15	avI6/avC12	VDD_h2 gpdk090_pmos1v	L=0.1U
+ W=0.48U
+ AD=0.1392P	AS=0.1392P	PD=1.06U	PS=1.06U
MavI6/avD7_3	avI6/avC13	RST_h21	VDD_h117	VDD_h2 gpdk090_pmos1v	L=0.1U
+ W=0.48U
+ AD=0.1392P	AS=0.1392P	PD=1.06U	PS=1.06U
MavI6/avD7_4	avI6/avC9_h2	CLK_h35	avI6/avC13	VDD_h2 gpdk090_pmos1v	L=0.1U
+ W=0.48U
+ AD=0.1968P	AS=0.1392P	PD=1.78U	PS=1.06U
MavI6/avD7_5	VDD_h116	avC1_6_h3	avI6/avC9	VDD_h2 gpdk090_pmos1v
+ L=0.4U	W=0.12U
+ AD=0.1086P	AS=0.078P	PD=1.06U	PS=1.3U
MavI6/avD7_6	avC1_6_h8	avI6/avC9_h10	VDD_h116	VDD_h2 gpdk090_pmos1v
+ L=0.1U	W=0.48U
+ AD=0.1968P	AS=0.1086P	PD=1.78U	PS=1.06U
MavI6/avD7_7	VDD_h115	Q2_h3	avC1_6_h6	VDD_h2 gpdk090_pmos1v	L=0.4U
+ W=0.12U
+ AD=0.1086P	AS=0.078P	PD=1.06U	PS=1.3U
MavI6/avD7_8	Q2_h4	avC1_6_h13	VDD_h115	VDD_h2 gpdk090_pmos1v	L=0.1U
+ W=0.48U
+ AD=0.1968P	AS=0.1086P	PD=1.78U	PS=1.06U
MavI5/avD7_1	avI5/avC12	CLK_h17	avI5/avC8	VDD_h2 gpdk090_pmos1v	L=0.1U
+ W=0.48U
+ AD=0.1392P	AS=0.1968P	PD=1.06U	PS=1.78U
MavI5/avD7_2	VDD_h120	Q0_h15	avI5/avC12	VDD_h2 gpdk090_pmos1v	L=0.1U
+ W=0.48U
+ AD=0.1392P	AS=0.1392P	PD=1.06U	PS=1.06U
MavI5/avD7_3	avI5/avC13	RST_h13	VDD_h120	VDD_h2 gpdk090_pmos1v	L=0.1U
+ W=0.48U
+ AD=0.1392P	AS=0.1392P	PD=1.06U	PS=1.06U
MavI5/avD7_4	avI5/avC9_h2	CLK_h20	avI5/avC13	VDD_h2 gpdk090_pmos1v	L=0.1U
+ W=0.48U
+ AD=0.1968P	AS=0.1392P	PD=1.78U	PS=1.06U
MavI5/avD7_5	VDD_h119	avC1_5_h3	avI5/avC9	VDD_h2 gpdk090_pmos1v
+ L=0.4U	W=0.12U
+ AD=0.1086P	AS=0.078P	PD=1.06U	PS=1.3U
MavI5/avD7_6	avC1_5_h8	avI5/avC9_h10	VDD_h119	VDD_h2 gpdk090_pmos1v
+ L=0.1U	W=0.48U
+ AD=0.1968P	AS=0.1086P	PD=1.78U	PS=1.06U
MavI5/avD7_7	VDD_h118	Q1_h3	avC1_5_h6	VDD_h2 gpdk090_pmos1v	L=0.4U
+ W=0.12U
+ AD=0.1086P	AS=0.078P	PD=1.06U	PS=1.3U
MavI5/avD7_8	Q1_h4	avC1_5_h13	VDD_h118	VDD_h2 gpdk090_pmos1v	L=0.1U
+ W=0.48U
+ AD=0.1968P	AS=0.1086P	PD=1.78U	PS=1.06U
MavI4/avD7_1	VDD_h97	avC15_h11	avI4/avC6	VDD_h2 gpdk090_pmos1v	L=0.1U
+ W=0.24U
+ AD=0.0816P	AS=0.0816P	PD=1.16U	PS=1.16U
MavI4/avD7_2	avC13_h9	avI4/avC6_h7	avI4/avC10_h2	VDD_h2 gpdk090_pmos1v
+ L=0.1U	W=0.48U
+ AD=0.1056P	AS=0.1632P	PD=0.92U	PS=1.64U
MavI4/avD7_3	avI4/avC10_h4	avI4/avC7_h3	avC13_h9	VDD_h2 gpdk090_pmos1v
+ L=0.1U	W=0.48U
+ AD=0.1056P	AS=0.1056P	PD=0.92U	PS=0.92U
MavI4/avD7_4	VDD_h96	avC14_h10	avI4/avC10_h4	VDD_h2 gpdk090_pmos1v	L=0.1U
+ W=0.48U
+ AD=0.1056P	AS=0.1056P	PD=0.92U	PS=0.92U
MavI4/avD7_5	avI4/avC10_h6	avC15_h17	VDD_h96	VDD_h2 gpdk090_pmos1v	L=0.1U
+ W=0.48U
+ AD=0.1632P	AS=0.1056P	PD=1.64U	PS=0.92U
MavI4/avD7_6	VDD_h1	avC14_h16	avI4/avC7_h5	VDD_h2 gpdk090_pmos1v	L=0.1U
+ W=0.24U
+ AD=0.0816P	AS=0.0816P	PD=1.16U	PS=1.16U
MavI3/avD7_1	VDD_h98	Q6_h21	avI3/avC6	VDD_h2 gpdk090_pmos1v	L=0.1U	W=0.24U
+ AD=0.0816P	AS=0.0816P	PD=1.16U	PS=1.16U
MavI3/avD7_2	avC15_h3	Q7_h14	Q6_h23	VDD_h2 gpdk090_pmos1v	L=0.1U	W=0.48U
+ AD=0.0936P	AS=0.1632P	PD=0.92U	PS=1.64U
MavI3/avD7_3	Q7_h16	Q6_h28	avC15_h3	VDD_h2 gpdk090_pmos1v	L=0.1U	W=0.24U
+ AD=0.0816P	AS=0.0936P	PD=1.16U	PS=0.92U
MavI2/avD7_1	VDD_h99	Q0_h21	avI2/avC6	VDD_h2 gpdk090_pmos1v	L=0.1U	W=0.24U
+ AD=0.0816P	AS=0.0816P	PD=1.16U	PS=1.16U
MavI2/avD7_2	avC14_h3	Q5_h22	Q0_h23	VDD_h2 gpdk090_pmos1v	L=0.1U	W=0.48U
+ AD=0.0936P	AS=0.1632P	PD=0.92U	PS=1.64U
MavI2/avD7_3	Q5_h24	Q0_h28	avC14_h3	VDD_h2 gpdk090_pmos1v	L=0.1U	W=0.24U
+ AD=0.0816P	AS=0.0936P	PD=1.16U	PS=0.92U
MavI1/avD7_1	avI1/avC12	CLK_h3	avI1/avC8	VDD_h2 gpdk090_pmos1v	L=0.1U
+ W=0.48U
+ AD=0.1392P	AS=0.1968P	PD=1.06U	PS=1.78U
MavI1/avD7_2	VDD_h128	avC13_h5	avI1/avC12	VDD_h2 gpdk090_pmos1v
+ L=0.1U	W=0.48U
+ AD=0.1392P	AS=0.1392P	PD=1.06U	PS=1.06U
MavI1/avD7_3	avI1/avC9_h5	CLK_h7	VDD_h128	VDD_h2 gpdk090_pmos1v	L=0.1U
+ W=0.48U
+ AD=0.1968P	AS=0.1392P	PD=1.78U	PS=1.06U
MavI1/avD7_4	VDD_h122	avC1_1_h5	avI1/avC9_h3	VDD_h2 gpdk090_pmos1v
+ L=0.4U	W=0.12U
+ AD=0.1086P	AS=0.078P	PD=1.06U	PS=1.3U
MavI1/avD7_5	avI1/avC13	RST_h5	VDD_h122	VDD_h2 gpdk090_pmos1v	L=0.1U
+ W=0.48U
+ AD=0.1392P	AS=0.1086P	PD=1.06U	PS=1.06U
MavI1/avD7_6	avC1_1_h10	avI1/avC9_h8	avI1/avC13	VDD_h2 gpdk090_pmos1v
+ L=0.1U	W=0.48U
+ AD=0.1968P	AS=0.1392P	PD=1.78U	PS=1.06U
MavI1/avD7_7	VDD_h121	Q0_h3	avC1_1_h8	VDD_h2 gpdk090_pmos1v	L=0.4U
+ W=0.12U
+ AD=0.1086P	AS=0.078P	PD=1.06U	PS=1.3U
MavI1/avD7_8	Q0_h4	avC1_1_h15	VDD_h121	VDD_h2 gpdk090_pmos1v	L=0.1U
+ W=0.48U
+ AD=0.1968P	AS=0.1086P	PD=1.78U	PS=1.06U
Rj1	CLK_h3	CLK_h2	   16.5435
Rj2	avC13_h5	avC13_h6	   28.5435
Rj3	avC13_h6	avC13_h7	   44.5435
Rj4	avC13_h2	avC13_h6	   10.0000
Rj5	CLK_h7	CLK_h8	   18.5435
Rj6	CLK_h8	CLK_h9	   42.5435
Rj7	CLK_h5	CLK_h8	   10.0000
Rj8	avI1/avC8_h7	avI1/avC8_h5	   16.5435
Rj9	avC1_1	avC1_1_h5	   52.2934
Rj10	RST_h5	RST_h6	   28.5435
Rj11	RST_h6	RST_h7	   44.5435
Rj12	RST_h2	RST_h6	   10.0000
Rj13	avI1/avC9_h8	avI1/avC9_h7	   28.5435
Rj14	avI1/avC9_h7	avI1/avC9_h9	   44.5435
Rj15	CLK_h14	CLK_h13	   54.5435
Rj16	Q0_h2	Q0_h3	   24.2934
Rj17	avC1_1_h15	avC1_1_h12	   44.5435
Rj18	avC1_1_h12	avC1_1_h16	   28.5435
Rj19	CLK_h17	CLK_h16	   16.5435
Rj20	Q0_h15	Q0_h16	   28.5435
Rj21	Q0_h16	Q0_h17	   44.5435
Rj22	Q0_h11	Q0_h16	   10.0000
Rj23	RST_h13	RST_h14	   28.5435
Rj24	RST_h14	RST_h15	   44.5435
Rj25	RST_h10	RST_h14	   10.0000
Rj26	CLK_h20	CLK_h19	   16.5435
Rj27	avI5/avC8_h7	avI5/avC8_h5	   16.5435
Rj28	CLK_h24	CLK_h22	   52.5435
Rj29	avC1_5	avC1_5_h3	   52.2934
Rj30	avI5/avC9_h10	avI5/avC9_h9	   28.5435
Rj31	avI5/avC9_h9	avI5/avC9_h11	   44.5435
Rj32	CLK_h28	CLK_h26	   54.5435
Rj33	Q1_h2	Q1_h3	   24.2934
Rj34	avC1_5_h13	avC1_5_h10	   44.5435
Rj35	avC1_5_h10	avC1_5_h14	   28.5435
Rj36	CLK_h32	CLK_h31	   16.5435
Rj37	Q1_h15	Q1_h16	   28.5435
Rj38	Q1_h16	Q1_h17	   44.5435
Rj39	Q1_h11	Q1_h16	   10.0000
Rj40	RST_h21	RST_h22	   28.5435
Rj41	RST_h22	RST_h23	   44.5435
Rj42	RST_h18	RST_h22	   10.0000
Rj43	CLK_h35	CLK_h34	   16.5435
Rj44	avI6/avC8_h7	avI6/avC8_h5	   16.5435
Rj45	CLK_h39	CLK_h37	   52.5435
Rj46	avC1_6	avC1_6_h3	   52.2934
Rj47	avI6/avC9_h10	avI6/avC9_h9	   28.5435
Rj48	avI6/avC9_h9	avI6/avC9_h11	   44.5435
Rj49	CLK_h43	CLK_h41	   54.5435
Rj50	Q2_h2	Q2_h3	   24.2934
Rj51	avC1_6_h13	avC1_6_h10	   44.5435
Rj52	avC1_6_h10	avC1_6_h14	   28.5435
Rj53	CLK_h47	CLK_h46	   16.5435
Rj54	Q2_h15	Q2_h16	   28.5435
Rj55	Q2_h16	Q2_h17	   44.5435
Rj56	Q2_h11	Q2_h16	   10.0000
Rj57	RST_h29	RST_h30	   28.5435
Rj58	RST_h30	RST_h31	   44.5435
Rj59	RST_h26	RST_h30	   10.0000
Rj60	CLK_h50	CLK_h49	   16.5435
Rj61	avI7/avC8_h7	avI7/avC8_h5	   16.5435
Rj62	CLK_h54	CLK_h52	   52.5435
Rj63	avC1_7	avC1_7_h3	   52.2934
Rj64	avI7/avC9_h10	avI7/avC9_h9	   28.5435
Rj65	avI7/avC9_h9	avI7/avC9_h11	   44.5435
Rj66	CLK_h58	CLK_h56	   54.5435
Rj67	Q3_h2	Q3_h3	   24.2934
Rj68	avC1_7_h13	avC1_7_h10	   44.5435
Rj69	avC1_7_h10	avC1_7_h14	   28.5435
Rj70	CLK_h62	CLK_h61	   16.5435
Rj71	Q3_h15	Q3_h16	   28.5435
Rj72	Q3_h16	Q3_h17	   44.5435
Rj73	Q3_h11	Q3_h16	   10.0000
Rj74	RST_h37	RST_h38	   28.5435
Rj75	RST_h38	RST_h39	   44.5435
Rj76	RST_h34	RST_h38	   10.0000
Rj77	CLK_h65	CLK_h64	   16.5435
Rj78	avI8/avC8_h7	avI8/avC8_h5	   16.5435
Rj79	CLK_h69	CLK_h67	   52.5435
Rj80	avC1_8	avC1_8_h3	   52.2934
Rj81	avI8/avC9_h10	avI8/avC9_h9	   28.5435
Rj82	avI8/avC9_h9	avI8/avC9_h11	   44.5435
Rj83	CLK_h73	CLK_h71	   54.5435
Rj84	Q4_h2	Q4_h3	   24.2934
Rj85	avC1_8_h13	avC1_8_h10	   44.5435
Rj86	avC1_8_h10	avC1_8_h14	   28.5435
Rj87	CLK_h77	CLK_h76	   16.5435
Rj88	Q4_h15	Q4_h16	   28.5435
Rj89	Q4_h16	Q4_h17	   44.5435
Rj90	Q4_h11	Q4_h16	   10.0000
Rj91	RST_h45	RST_h46	   28.5435
Rj92	RST_h46	RST_h47	   44.5435
Rj93	RST_h42	RST_h46	   10.0000
Rj94	CLK_h80	CLK_h79	   16.5435
Rj95	avI9/avC8_h7	avI9/avC8_h5	   16.5435
Rj96	CLK_h84	CLK_h82	   52.5435
Rj97	avC1_9	avC1_9_h3	   52.2934
Rj98	avI9/avC9_h10	avI9/avC9_h9	   28.5435
Rj99	avI9/avC9_h9	avI9/avC9_h11	   44.5435
Rj100	CLK_h88	CLK_h86	   54.5435
Rj101	Q5_h2	Q5_h3	   24.2934
Rj102	avC1_9_h13	avC1_9_h10	   44.5435
Rj103	avC1_9_h10	avC1_9_h14	   28.5435
Rj104	CLK_h92	CLK_h91	   16.5435
Rj105	Q5_h15	Q5_h16	   28.5435
Rj106	Q5_h16	Q5_h17	   44.5435
Rj107	Q5_h11	Q5_h16	   10.0000
Rj108	RST_h53	RST_h54	   28.5435
Rj109	RST_h54	RST_h55	   44.5435
Rj110	RST_h50	RST_h54	   10.0000
Rj111	CLK_h95	CLK_h94	   16.5435
Rj112	avI10/avC8_h7	avI10/avC8_h5	   16.5435
Rj113	CLK_h99	CLK_h97	   52.5435
Rj114	avC1_10	avC1_10_h3	   52.2934
Rj115	avI10/avC9_h10	avI10/avC9_h9	   28.5435
Rj116	avI10/avC9_h9	avI10/avC9_h11	   44.5435
Rj117	CLK_h103	CLK_h101	   54.5435
Rj118	Q6_h2	Q6_h3	   24.2934
Rj119	avC1_10_h13	avC1_10_h10	   44.5435
Rj120	avC1_10_h10	avC1_10_h14	   28.5435
Rj121	CLK_h107	CLK_h106	   16.5435
Rj122	Q6_h15	Q6_h16	   28.5435
Rj123	Q6_h16	Q6_h17	   44.5435
Rj124	Q6_h11	Q6_h16	   10.0000
Rj125	RST_h61	RST_h62	   28.5435
Rj126	RST_h62	RST_h63	   44.5435
Rj127	RST_h58	RST_h62	   10.0000
Rj128	CLK_h110	CLK_h109	   16.5435
Rj129	avI11/avC8_h7	avI11/avC8_h5	   16.5435
Rj130	CLK_h114	CLK_h112	   52.5435
Rj131	avC1_11	avC1_11_h3	   52.2934
Rj132	avI11/avC9_h10	avI11/avC9_h9	   28.5435
Rj133	avI11/avC9_h9	avI11/avC9_h11	   44.5435
Rj134	CLK_h119	CLK_h117	   54.5435
Rj135	Q7_h2	Q7_h3	   24.2934
Rj136	avC1_11_h13	avC1_11_h10	   44.5435
Rj137	avC1_11_h10	avC1_11_h14	   28.5435
Rj138	Q0_h21	Q0_h18	   58.5435
Rj139	avI2/avC6_h5	avI2/avC6_h3	   54.5435
Rj140	Q5_h22	Q5_h20	   36.5435
Rj141	Q5_h20	Q5_h23	   48.5435
Rj142	Q0_h28	Q0_h26	   48.5435
Rj143	Q0_h26	Q0_h29	   54.5435
Rj144	Q6_h21	Q6_h18	   58.5435
Rj145	avI3/avC6_h5	avI3/avC6_h3	   54.5435
Rj146	Q7_h14	Q7_h12	   36.5435
Rj147	Q7_h12	Q7_h15	   48.5435
Rj148	Q6_h28	Q6_h26	   48.5435
Rj149	Q6_h26	Q6_h29	   54.5435
Rj150	avC15_h11	avC15_h8	   48.5435
Rj151	avC15_h8	avC15_h12	   54.5435
Rj152	avI4/avC6_h7	avI4/avC6_h5	   36.5435
Rj153	avI4/avC6_h5	avI4/avC6_h8	   48.5435
Rj154	avI4/avC7_h3	avI4/avC7	   36.5435
Rj155	avI4/avC7	avI4/avC7_h4	   48.5435
Rj156	avC14_h10	avC14_h8	   36.5435
Rj157	avC14_h8	avC14_h11	   48.5435
Rj158	avC15_h17	avC15_h15	   36.5435
Rj159	avC15_h15	avC15_h18	   48.5435
Rj160	avC14_h16	avC14_h17	   48.5435
Rj161	avC14_h17	avC14_h18	   54.5435
Rj162	avC14_h12	avC14_h17	   10.0000
Ri1	avI1/avC8	avI1/avC8_h2	   16.7081
Ri2	CLK_h1	CLK_h2	   11.6192
Ri3	avI1/avC8_h3	avI1/avC8_h4	   16.8414
Ri4	avC13	avC13_h2	    1.9133
Ri6	CLK_h4	CLK_h5	    1.6059
Ri8	avI1/avC8_h5	avI1/avC8_h6	   11.4913
Ri9	avI1/avC9	avI1/avC9_h2	   15.7054
Ri10	avI1/avC9_h2	avI1/avC9_h4	3.692E-02
Ri11	avI1/avC9_h2	avI1/avC9_h5	   15.3916
Ri12	avI1/avC9_h3	avI1/avC9_h4	   15.0000
Ri13	avC1_1	avC1_1_h2	   11.4913
Ri14	avC1_1_h3	avC1_1_h4	   16.8414
Ri15	RST_h1	RST_h2	    1.9133
Ri17	avI1/avC9_h6	avI1/avC9_h7	   11.6592
Ri18	CLK_h12	CLK_h13	   11.6059
Ri19	avC1_1_h6	avC1_1_h7	    0.2814
Ri20	avC1_1_h7	avC1_1_h9	    0.3081
Ri21	avC1_1_h9	avC1_1_h10	   15.4200
Ri22	avC1_1_h6	avC1_1_h11	   15.1600
Ri23	avC1_1_h8	avC1_1_h9	   15.0000
Ri24	Q0_h1	Q0_h2	   11.6192
Ri25	avC1_1_h12	avC1_1_h13	   11.4913
Ri26	Q0_h4	Q0_h5	   15.5152
Ri27	Q0_h5	Q0_h6	3.333E-02
Ri28	Q0_h6	Q0_h7	   15.1600
Ri29	avI5/avC8	avI5/avC8_h2	   16.7081
Ri30	CLK_h15	CLK_h16	   11.6192
Ri31	avI5/avC8_h3	avI5/avC8_h4	   16.8414
Ri32	Q0_h10	Q0_h11	    1.9133
Ri34	RST_h9	RST_h10	    1.9133
Ri36	CLK_h18	CLK_h19	   11.6192
Ri37	avI5/avC8_h5	avI5/avC8_h6	   11.4913
Ri38	CLK_h21	CLK_h22	    1.6059
Ri40	avI5/avC9	avI5/avC9_h3	   15.9152
Ri42	avI5/avC9_h3	avI5/avC9_h6	    0.7054
Ri43	avI5/avC9_h6	avI5/avC9_h7	   15.4200
Ri44	avI5/avC9_h2	avI5/avC9_h3	   15.0000
Ri45	avI5/avC9_h5	avI5/avC9_h6	   15.0000
Ri46	avC1_5	avC1_5_h2	   11.4913
Ri47	avI5/avC9_h8	avI5/avC9_h9	   11.6592
Ri48	CLK_h25	CLK_h26	   11.6059
Ri49	avC1_5_h4	avC1_5_h5	    0.2814
Ri50	avC1_5_h5	avC1_5_h7	    0.3081
Ri51	avC1_5_h7	avC1_5_h8	   15.4200
Ri52	avC1_5_h4	avC1_5_h9	   15.1600
Ri53	avC1_5_h6	avC1_5_h7	   15.0000
Ri54	Q1_h1	Q1_h2	   11.6192
Ri55	avC1_5_h10	avC1_5_h11	   11.4913
Ri56	Q1_h4	Q1_h5	   15.5152
Ri57	Q1_h5	Q1_h6	3.333E-02
Ri58	Q1_h6	Q1_h7	   15.1600
Ri59	avI6/avC8	avI6/avC8_h2	   16.7081
Ri60	CLK_h30	CLK_h31	   11.6192
Ri61	avI6/avC8_h3	avI6/avC8_h4	   16.8414
Ri62	Q1_h10	Q1_h11	    1.9133
Ri64	RST_h17	RST_h18	    1.9133
Ri66	CLK_h33	CLK_h34	   11.6192
Ri67	avI6/avC8_h5	avI6/avC8_h6	   11.4913
Ri68	CLK_h36	CLK_h37	    1.6059
Ri70	avI6/avC9	avI6/avC9_h3	   15.9152
Ri72	avI6/avC9_h3	avI6/avC9_h6	    0.7054
Ri73	avI6/avC9_h6	avI6/avC9_h7	   15.4200
Ri74	avI6/avC9_h2	avI6/avC9_h3	   15.0000
Ri75	avI6/avC9_h5	avI6/avC9_h6	   15.0000
Ri76	avC1_6	avC1_6_h2	   11.4913
Ri77	avI6/avC9_h8	avI6/avC9_h9	   11.6592
Ri78	CLK_h40	CLK_h41	   11.6059
Ri79	avC1_6_h4	avC1_6_h5	    0.2814
Ri80	avC1_6_h5	avC1_6_h7	    0.3081
Ri81	avC1_6_h7	avC1_6_h8	   15.4200
Ri82	avC1_6_h4	avC1_6_h9	   15.1600
Ri83	avC1_6_h6	avC1_6_h7	   15.0000
Ri84	Q2_h1	Q2_h2	   11.6192
Ri85	avC1_6_h10	avC1_6_h11	   11.4913
Ri86	Q2_h4	Q2_h5	   15.5152
Ri87	Q2_h5	Q2_h6	3.333E-02
Ri88	Q2_h6	Q2_h7	   15.1600
Ri89	avI7/avC8	avI7/avC8_h2	   16.7081
Ri90	CLK_h45	CLK_h46	   11.6192
Ri91	avI7/avC8_h3	avI7/avC8_h4	   16.8414
Ri92	Q2_h10	Q2_h11	    1.9133
Ri94	RST_h25	RST_h26	    1.9133
Ri96	CLK_h48	CLK_h49	   11.6192
Ri97	avI7/avC8_h5	avI7/avC8_h6	   11.4913
Ri98	CLK_h51	CLK_h52	    1.6059
Ri100	avI7/avC9	avI7/avC9_h3	   15.9152
Ri102	avI7/avC9_h3	avI7/avC9_h6	    0.7054
Ri103	avI7/avC9_h6	avI7/avC9_h7	   15.4200
Ri104	avI7/avC9_h2	avI7/avC9_h3	   15.0000
Ri105	avI7/avC9_h5	avI7/avC9_h6	   15.0000
Ri106	avC1_7	avC1_7_h2	   11.4913
Ri107	avI7/avC9_h8	avI7/avC9_h9	   11.6592
Ri108	CLK_h55	CLK_h56	   11.6059
Ri109	avC1_7_h4	avC1_7_h5	    0.2814
Ri110	avC1_7_h5	avC1_7_h7	    0.3081
Ri111	avC1_7_h7	avC1_7_h8	   15.4200
Ri112	avC1_7_h4	avC1_7_h9	   15.1600
Ri113	avC1_7_h6	avC1_7_h7	   15.0000
Ri114	Q3_h1	Q3_h2	   11.6192
Ri115	avC1_7_h10	avC1_7_h11	   11.4913
Ri116	Q3_h4	Q3_h5	   15.5152
Ri117	Q3_h5	Q3_h6	3.333E-02
Ri118	Q3_h6	Q3_h7	   15.1600
Ri119	avI8/avC8	avI8/avC8_h2	   16.7081
Ri120	CLK_h60	CLK_h61	   11.6192
Ri121	avI8/avC8_h3	avI8/avC8_h4	   16.8414
Ri122	Q3_h10	Q3_h11	    1.9133
Ri124	RST_h33	RST_h34	    1.9133
Ri126	CLK_h63	CLK_h64	   11.6192
Ri127	avI8/avC8_h5	avI8/avC8_h6	   11.4913
Ri128	CLK_h66	CLK_h67	    1.6059
Ri130	avI8/avC9	avI8/avC9_h3	   15.9152
Ri132	avI8/avC9_h3	avI8/avC9_h6	    0.7054
Ri133	avI8/avC9_h6	avI8/avC9_h7	   15.4200
Ri134	avI8/avC9_h2	avI8/avC9_h3	   15.0000
Ri135	avI8/avC9_h5	avI8/avC9_h6	   15.0000
Ri136	avC1_8	avC1_8_h2	   11.4913
Ri137	avI8/avC9_h8	avI8/avC9_h9	   11.6592
Ri138	CLK_h70	CLK_h71	   11.6059
Ri139	avC1_8_h4	avC1_8_h5	    0.2814
Ri140	avC1_8_h5	avC1_8_h7	    0.3081
Ri141	avC1_8_h7	avC1_8_h8	   15.4200
Ri142	avC1_8_h4	avC1_8_h9	   15.1600
Ri143	avC1_8_h6	avC1_8_h7	   15.0000
Ri144	Q4_h1	Q4_h2	   11.6192
Ri145	avC1_8_h10	avC1_8_h11	   11.4913
Ri146	Q4_h4	Q4_h5	   15.5152
Ri147	Q4_h5	Q4_h6	3.333E-02
Ri148	Q4_h6	Q4_h7	   15.1600
Ri149	avI9/avC8	avI9/avC8_h2	   16.7081
Ri150	CLK_h75	CLK_h76	   11.6192
Ri151	avI9/avC8_h3	avI9/avC8_h4	   16.8414
Ri152	Q4_h10	Q4_h11	    1.9133
Ri154	RST_h41	RST_h42	    1.9133
Ri156	CLK_h78	CLK_h79	   11.6192
Ri157	avI9/avC8_h5	avI9/avC8_h6	   11.4913
Ri158	CLK_h81	CLK_h82	    1.6059
Ri160	avI9/avC9	avI9/avC9_h3	   15.9152
Ri162	avI9/avC9_h3	avI9/avC9_h6	    0.7054
Ri163	avI9/avC9_h6	avI9/avC9_h7	   15.4200
Ri164	avI9/avC9_h2	avI9/avC9_h3	   15.0000
Ri165	avI9/avC9_h5	avI9/avC9_h6	   15.0000
Ri166	avC1_9	avC1_9_h2	   11.4913
Ri167	avI9/avC9_h8	avI9/avC9_h9	   11.6592
Ri168	CLK_h85	CLK_h86	   11.6059
Ri169	avC1_9_h4	avC1_9_h5	    0.2814
Ri170	avC1_9_h5	avC1_9_h7	    0.3081
Ri171	avC1_9_h7	avC1_9_h8	   15.4200
Ri172	avC1_9_h4	avC1_9_h9	   15.1600
Ri173	avC1_9_h6	avC1_9_h7	   15.0000
Ri174	Q5_h1	Q5_h2	   11.6192
Ri175	avC1_9_h10	avC1_9_h11	   11.4913
Ri176	Q5_h4	Q5_h5	   15.5152
Ri177	Q5_h5	Q5_h6	3.333E-02
Ri178	Q5_h6	Q5_h7	   15.1600
Ri179	avI10/avC8	avI10/avC8_h2	   16.7081
Ri180	CLK_h90	CLK_h91	   11.6192
Ri181	avI10/avC8_h3	avI10/avC8_h4	   16.8414
Ri182	Q5_h10	Q5_h11	    1.9133
Ri184	RST_h49	RST_h50	    1.9133
Ri186	CLK_h93	CLK_h94	   11.6192
Ri187	avI10/avC8_h5	avI10/avC8_h6	   11.4913
Ri188	CLK_h96	CLK_h97	    1.6059
Ri190	avI10/avC9	avI10/avC9_h3	   15.9152
Ri192	avI10/avC9_h3	avI10/avC9_h6	    0.7054
Ri193	avI10/avC9_h6	avI10/avC9_h7	   15.4200
Ri194	avI10/avC9_h2	avI10/avC9_h3	   15.0000
Ri195	avI10/avC9_h5	avI10/avC9_h6	   15.0000
Ri196	avC1_10	avC1_10_h2	   11.4913
Ri197	avI10/avC9_h8	avI10/avC9_h9	   11.6592
Ri198	CLK_h100	CLK_h101	   11.6059
Ri199	avC1_10_h4	avC1_10_h5	    0.2814
Ri200	avC1_10_h5	avC1_10_h7	    0.3081
Ri201	avC1_10_h7	avC1_10_h8	   15.4200
Ri202	avC1_10_h4	avC1_10_h9	   15.1600
Ri203	avC1_10_h6	avC1_10_h7	   15.0000
Ri204	Q6_h1	Q6_h2	   11.6192
Ri205	avC1_10_h10	avC1_10_h11	   11.4913
Ri206	Q6_h4	Q6_h5	   15.5152
Ri207	Q6_h5	Q6_h6	3.333E-02
Ri208	Q6_h6	Q6_h7	   15.1600
Ri209	avI11/avC8	avI11/avC8_h2	   16.7081
Ri210	CLK_h105	CLK_h106	   11.6192
Ri211	avI11/avC8_h3	avI11/avC8_h4	   16.8414
Ri212	Q6_h10	Q6_h11	    1.9133
Ri214	RST_h57	RST_h58	    1.9133
Ri216	CLK_h108	CLK_h109	   11.6192
Ri217	avI11/avC8_h5	avI11/avC8_h6	   11.4913
Ri218	CLK_h111	CLK_h112	    1.6059
Ri220	avI11/avC9	avI11/avC9_h3	   15.9152
Ri222	avI11/avC9_h3	avI11/avC9_h6	    0.7054
Ri223	avI11/avC9_h6	avI11/avC9_h7	   15.4200
Ri224	avI11/avC9_h2	avI11/avC9_h3	   15.0000
Ri225	avI11/avC9_h5	avI11/avC9_h6	   15.0000
Ri226	avC1_11	avC1_11_h2	   11.4913
Ri227	avI11/avC9_h8	avI11/avC9_h9	   11.6592
Ri228	CLK_h116	CLK_h117	   11.6059
Ri229	avC1_11_h4	avC1_11_h5	    0.2814
Ri230	avC1_11_h5	avC1_11_h7	    0.3081
Ri231	avC1_11_h7	avC1_11_h8	   15.4200
Ri232	avC1_11_h4	avC1_11_h9	   15.1600
Ri233	avC1_11_h6	avC1_11_h7	   15.0000
Ri234	Q7_h1	Q7_h2	   11.6192
Ri235	avC1_11_h10	avC1_11_h11	   11.4913
Ri236	Q7_h4	Q7_h5	   15.5152
Ri237	Q7_h5	Q7_h6	3.333E-02
Ri238	Q7_h6	Q7_h7	   15.1600
Ri239	avI2/avC6	avI2/avC6_h2	   17.0453
Ri240	Q0_h18	Q0_h19	6.133E-02
Ri241	Q0_h19	Q0_h20	    1.6747
Ri242	Q5_h18	Q5_h19	   16.6347
Ri243	avI2/avC6_h3	avI2/avC6_h4	   11.6827
Ri244	Q0_h22	Q0_h23	   16.4267
Ri245	avC14	avC14_h2	   16.7893
Ri246	Q5_h20	Q5_h21	   11.5280
Ri247	avC14_h3	avC14_h4	   15.3013
Ri248	avC14_h4	avC14_h5	    1.4347
Ri249	avI2/avC6_h6	avI2/avC6_h7	   16.4800
Ri250	Q0_h26	Q0_h27	   11.7360
Ri251	Q5_h24	Q5_h25	   15.3600
Ri252	Q5_h25	Q5_h26	    1.5307
Ri253	avI3/avC6	avI3/avC6_h2	   17.0453
Ri254	Q6_h18	Q6_h19	6.133E-02
Ri255	Q6_h19	Q6_h20	    1.6747
Ri256	Q7_h10	Q7_h11	   16.6347
Ri257	avI3/avC6_h3	avI3/avC6_h4	   11.6827
Ri258	Q6_h22	Q6_h23	   16.4267
Ri259	avC15	avC15_h2	   16.7893
Ri260	Q7_h12	Q7_h13	   11.5280
Ri261	avC15_h3	avC15_h4	   15.3013
Ri262	avC15_h4	avC15_h5	    1.4347
Ri263	avI3/avC6_h6	avI3/avC6_h7	   16.4800
Ri264	Q6_h26	Q6_h27	   11.7360
Ri265	Q7_h16	Q7_h17	   15.3600
Ri266	Q7_h17	Q7_h18	    1.5307
Ri267	avI4/avC6	avI4/avC6_h2	   16.8907
Ri268	avC15_h8	avC15_h9	   10.0267
Ri269	avC15_h9	avC15_h10	3.467E-02
Ri270	avI4/avC6_h3	avI4/avC6_h4	   16.6347
Ri271	avI4/avC10	avI4/avC10_h2	   16.4267
Ri272	avI4/avC6_h5	avI4/avC6_h6	   11.5280
Ri273	avC13_h9	avC13_h10	   17.0453
Ri274	avI4/avC7	avI4/avC7_h2	   11.5280
Ri275	avI4/avC10_h3	avI4/avC10_h4	   16.4267
Ri276	avC13_h11	avC13_h12	   15.0453
Ri277	avC13_h12	avC13_h13	    1.4347
Ri278	avC14_h8	avC14_h9	   11.5813
Ri279	avC15_h15	avC15_h16	   11.4267
Ri280	avI4/avC10_h5	avI4/avC10_h6	   15.0267
Ri281	avI4/avC7_h5	avI4/avC7_h6	   16.8907
Ri282	avC14_h12	avC14_h13	6.133E-02
Ri283	avC14_h13	avC14_h14	    1.5200
Ri284	avI4/avC7_h7	avI4/avC7_h8	   16.6347
Ri285	VDD_h1	VDD	   15.4271
Ri286	VDD_h3	VDD	    9.8880
Ri287	VDD_h4	VDD	    8.8800
Ri288	VDD_h5	VDD	    8.1600
Ri289	VDD_h6	VDD	    7.7200
Ri290	VDD_h7	VDD	    7.5387
Ri291	VDD_h8	VDD	    7.2773
Ri292	VDD_h9	VDD	    7.0960
Ri293	VDD_h10	VDD	    6.9147
Ri294	VDD_h11	VDD	    6.6533
Ri295	VDD_h12	VDD	    6.4720
Ri296	VDD_h13	VDD	    6.2907
Ri297	VDD_h14	VDD	    6.1093
Ri298	VDD_h15	VDD	    5.9280
Ri299	VDD_h16	VDD	    5.7467
Ri300	VDD_h17	VDD	    5.5653
Ri301	VDD_h18	VDD	    5.4053
Ri302	VDD_h19	VDD	    5.2240
Ri303	VDD_h20	VDD	    4.9627
Ri304	VDD_h21	VDD	    4.7813
Ri305	VDD_h22	VDD	    4.6000
Ri306	VDD_h23	VDD	    4.3387
Ri307	VDD_h24	VDD	    4.1573
Ri308	VDD_h25	VDD	    3.9760
Ri309	VDD_h26	VDD	    3.7947
Ri310	VDD_h27	VDD	    3.6133
Ri311	VDD_h28	VDD	    3.4320
Ri312	VDD_h29	VDD	    3.2507
Ri313	VDD_h30	VDD	    3.0907
Ri314	VDD_h31	VDD	    2.9093
Ri315	VDD_h32	VDD	    2.6480
Ri316	VDD_h33	VDD	    2.4667
Ri317	VDD_h34	VDD	    2.2853
Ri318	VDD_h35	VDD	    2.0240
Ri319	VDD_h36	VDD	    1.8427
Ri320	VDD_h37	VDD	    1.6613
Ri321	VDD_h38	VDD	    1.4800
Ri322	VDD_h39	VDD	    1.2987
Ri323	VDD_h40	VDD	    1.1173
Ri324	VDD_h41	VDD	    0.9360
Ri325	VDD_h42	VDD	    0.7760
Ri326	VDD_h43	VDD	    0.5947
Ri327	VDD_h44	VDD	    0.3333
Ri328	VDD_h45	VDD	    0.1520
Ri329	VDD	VDD_h46	2.933E-02
Ri330	VDD	VDD_h47	    0.2907
Ri331	VDD	VDD_h48	    0.4720
Ri332	VDD	VDD_h49	    0.6533
Ri333	VDD	VDD_h50	    0.8347
Ri334	VDD	VDD_h51	    1.0160
Ri335	VDD	VDD_h52	    1.1973
Ri336	VDD	VDD_h53	    1.3787
Ri337	VDD	VDD_h54	    1.5387
Ri338	VDD	VDD_h55	    1.7200
Ri339	VDD	VDD_h56	    1.9813
Ri340	VDD	VDD_h57	    2.1627
Ri341	VDD	VDD_h58	    2.3440
Ri342	VDD	VDD_h59	    2.6053
Ri343	VDD	VDD_h60	    2.7867
Ri344	VDD	VDD_h61	    2.9680
Ri345	VDD	VDD_h62	    3.1493
Ri346	VDD	VDD_h63	    3.3307
Ri347	VDD	VDD_h64	    3.5120
Ri348	VDD	VDD_h65	    3.6933
Ri349	VDD	VDD_h66	    3.8533
Ri350	VDD	VDD_h67	    4.0347
Ri351	VDD	VDD_h68	    4.2960
Ri352	VDD	VDD_h69	    4.4773
Ri353	VDD	VDD_h70	    4.6587
Ri354	VDD	VDD_h71	    4.9200
Ri355	VDD	VDD_h72	    5.1013
Ri356	VDD	VDD_h73	    5.2827
Ri357	VDD	VDD_h74	    5.4640
Ri358	VDD	VDD_h75	    5.6453
Ri359	VDD	VDD_h76	    5.8267
Ri360	VDD	VDD_h77	    6.0080
Ri361	VDD	VDD_h78	    6.1680
Ri362	VDD	VDD_h79	    6.3493
Ri363	VDD	VDD_h80	    6.6107
Ri364	VDD	VDD_h81	    6.7920
Ri365	VDD	VDD_h82	    6.9733
Ri366	VDD	VDD_h83	    7.2347
Ri367	VDD	VDD_h84	    7.4160
Ri368	VDD	VDD_h85	    7.5973
Ri369	VDD	VDD_h86	    7.7787
Ri370	VDD	VDD_h87	    7.9600
Ri371	VDD	VDD_h88	    8.1413
Ri372	VDD	VDD_h89	    8.3227
Ri373	VDD	VDD_h90	    8.4827
Ri374	VDD	VDD_h91	    8.6640
Ri375	VDD_h92	VDD	    8.9253
Ri376	VDD	VDD_h93	    9.1067
Ri377	VDD_h93	VDD_h94	    0.1813
Ri378	VDD_h94	VDD_h95	    0.1813
Ri379	VDD	VDD_h96	   15.4271
Ri380	VDD	VDD_h97	   15.4271
Ri381	VDD	VDD_h98	   15.4271
Ri382	VDD	VDD_h99	   15.4271
Ri383	VDD	VDD_h100	   15.5021
Ri384	VDD	VDD_h101	   15.5021
Ri385	VDD	VDD_h102	   15.5021
Ri386	VDD	VDD_h103	   15.5021
Ri387	VDD	VDD_h104	   15.5021
Ri388	VDD	VDD_h105	   15.5021
Ri389	VDD	VDD_h106	   15.5021
Ri390	VDD	VDD_h107	   15.5021
Ri391	VDD	VDD_h108	   15.5021
Ri392	VDD	VDD_h109	   15.5021
Ri393	VDD_h46	VDD_h110	   15.5067
Ri394	VDD_h51	VDD_h111	   15.5067
Ri395	VDD_h55	VDD_h112	   15.5067
Ri396	VDD_h58	VDD_h113	   15.5067
Ri397	VDD_h63	VDD_h114	   15.5067
Ri398	VDD_h67	VDD_h115	   15.5067
Ri399	VDD_h70	VDD_h116	   15.5067
Ri400	VDD_h75	VDD_h117	   15.5067
Ri401	VDD_h79	VDD_h118	   15.5067
Ri402	VDD_h82	VDD_h119	   15.5067
Ri403	VDD_h87	VDD_h120	   15.5067
Ri404	VDD_h91	VDD_h121	   15.5067
Ri405	VDD_h95	VDD_h122	   15.4977
Ri406	VDD_h123	VDD	    9.7307
Ri407	VDD	VDD_h124	    9.9120
Ri408	VDD_h124	VDD_h125	    0.1813
Ri409	VDD_h125	VDD_h126	    0.1813
Ri410	VDD_h126	VDD_h127	    0.1813
Ri411	VDD_h127	VDD	5.260E-03
Ri412	VDD	VDD_h128	   15.4282
Ri413	VDD_h2	VDD_h3	    0.8824
Ri414	VDD_h2	VDD_h4	    1.6667
Ri415	VDD_h2	VDD_h5	    1.6667
Ri416	VDD_h2	VDD_h6	   15.0000
Ri417	VDD_h2	VDD_h7	   15.0000
Ri418	VDD_h2	VDD_h8	   15.0000
Ri419	VDD_h2	VDD_h9	   15.0000
Ri420	VDD_h2	VDD_h10	   15.0000
Ri421	VDD_h2	VDD_h11	   15.0000
Ri422	VDD_h2	VDD_h12	   15.0000
Ri423	VDD_h2	VDD_h13	   15.0000
Ri424	VDD_h2	VDD_h14	   15.0000
Ri425	VDD_h2	VDD_h15	   15.0000
Ri426	VDD_h2	VDD_h16	   15.0000
Ri427	VDD_h2	VDD_h17	   15.0000
Ri428	VDD_h2	VDD_h18	   15.0000
Ri429	VDD_h2	VDD_h19	   15.0000
Ri430	VDD_h2	VDD_h20	   15.0000
Ri431	VDD_h2	VDD_h21	   15.0000
Ri432	VDD_h2	VDD_h22	   15.0000
Ri433	VDD_h2	VDD_h23	   15.0000
Ri434	VDD_h2	VDD_h24	   15.0000
Ri435	VDD_h2	VDD_h25	   15.0000
Ri436	VDD_h2	VDD_h26	   15.0000
Ri437	VDD_h2	VDD_h27	   15.0000
Ri438	VDD_h2	VDD_h28	   15.0000
Ri439	VDD_h2	VDD_h29	   15.0000
Ri440	VDD_h2	VDD_h30	   15.0000
Ri441	VDD_h2	VDD_h31	   15.0000
Ri442	VDD_h2	VDD_h32	   15.0000
Ri443	VDD_h2	VDD_h33	   15.0000
Ri444	VDD_h2	VDD_h34	   15.0000
Ri445	VDD_h2	VDD_h35	   15.0000
Ri446	VDD_h2	VDD_h36	   15.0000
Ri447	VDD_h2	VDD_h37	   15.0000
Ri448	VDD_h2	VDD_h38	   15.0000
Ri449	VDD_h2	VDD_h39	   15.0000
Ri450	VDD_h2	VDD_h40	   15.0000
Ri451	VDD_h2	VDD_h41	   15.0000
Ri452	VDD_h2	VDD_h42	   15.0000
Ri453	VDD_h2	VDD_h43	   15.0000
Ri454	VDD_h2	VDD_h44	   15.0000
Ri455	VDD_h2	VDD_h45	   15.0000
Ri456	VDD_h2	VDD_h46	   15.0000
Ri457	VDD_h2	VDD_h47	   15.0000
Ri458	VDD_h2	VDD_h48	   15.0000
Ri459	VDD_h2	VDD_h49	   15.0000
Ri460	VDD_h2	VDD_h50	   15.0000
Ri461	VDD_h2	VDD_h51	   15.0000
Ri462	VDD_h2	VDD_h52	   15.0000
Ri463	VDD_h2	VDD_h53	   15.0000
Ri464	VDD_h2	VDD_h54	   15.0000
Ri465	VDD_h2	VDD_h55	   15.0000
Ri466	VDD_h2	VDD_h56	   15.0000
Ri467	VDD_h2	VDD_h57	   15.0000
Ri468	VDD_h2	VDD_h58	   15.0000
Ri469	VDD_h2	VDD_h59	   15.0000
Ri470	VDD_h2	VDD_h60	   15.0000
Ri471	VDD_h2	VDD_h61	   15.0000
Ri472	VDD_h2	VDD_h62	   15.0000
Ri473	VDD_h2	VDD_h63	   15.0000
Ri474	VDD_h2	VDD_h64	   15.0000
Ri475	VDD_h2	VDD_h65	   15.0000
Ri476	VDD_h2	VDD_h66	   15.0000
Ri477	VDD_h2	VDD_h67	   15.0000
Ri478	VDD_h2	VDD_h68	   15.0000
Ri479	VDD_h2	VDD_h69	   15.0000
Ri480	VDD_h2	VDD_h70	   15.0000
Ri481	VDD_h2	VDD_h71	   15.0000
Ri482	VDD_h2	VDD_h72	   15.0000
Ri483	VDD_h2	VDD_h73	   15.0000
Ri484	VDD_h2	VDD_h74	   15.0000
Ri485	VDD_h2	VDD_h75	   15.0000
Ri486	VDD_h2	VDD_h76	   15.0000
Ri487	VDD_h2	VDD_h77	   15.0000
Ri488	VDD_h2	VDD_h78	   15.0000
Ri489	VDD_h2	VDD_h79	   15.0000
Ri490	VDD_h2	VDD_h80	   15.0000
Ri491	VDD_h2	VDD_h81	   15.0000
Ri492	VDD_h2	VDD_h82	   15.0000
Ri493	VDD_h2	VDD_h83	   15.0000
Ri494	VDD_h2	VDD_h84	   15.0000
Ri495	VDD_h2	VDD_h85	   15.0000
Ri496	VDD_h2	VDD_h86	   15.0000
Ri497	VDD_h2	VDD_h87	   15.0000
Ri498	VDD_h2	VDD_h88	   15.0000
Ri499	VDD_h2	VDD_h89	   15.0000
Ri500	VDD_h2	VDD_h90	   15.0000
Ri501	VDD_h2	VDD_h91	   15.0000
Ri502	VDD_h2	VDD_h92	   15.0000
Ri503	VDD_h2	VDD_h93	   15.0000
Ri504	VDD_h2	VDD_h94	   15.0000
Ri505	VDD_h2	VDD_h95	   15.0000
Ri506	VDD_h2	VDD_h123	   15.0000
Ri507	VDD_h2	VDD_h124	   15.0000
Ri508	VDD_h2	VDD_h125	   15.0000
Ri509	VDD_h2	VDD_h126	   15.0000
Ri510	VDD_h2	VDD_h127	   15.0000
Ri511	GND_h1	GND	   15.3631
Ri512	GND_h3	GND	    9.8880
Ri513	GND_h4	GND	    8.8800
Ri514	GND_h5	GND	    8.1600
Ri515	GND_h6	GND	    7.7200
Ri516	GND_h7	GND	    7.5387
Ri517	GND_h8	GND	    7.2773
Ri518	GND_h9	GND	    7.0960
Ri519	GND_h10	GND	    6.9147
Ri520	GND_h11	GND	    6.6533
Ri521	GND_h12	GND	    6.4720
Ri522	GND_h13	GND	    6.2907
Ri523	GND_h14	GND	    6.1093
Ri524	GND_h15	GND	    5.9280
Ri525	GND_h16	GND	    5.7467
Ri526	GND_h17	GND	    5.5653
Ri527	GND_h18	GND	    5.4053
Ri528	GND_h19	GND	    5.2240
Ri529	GND_h20	GND	    4.9627
Ri530	GND_h21	GND	    4.7813
Ri531	GND_h22	GND	    4.6000
Ri532	GND_h23	GND	    4.3387
Ri533	GND_h24	GND	    4.1573
Ri534	GND_h25	GND	    3.9760
Ri535	GND_h26	GND	    3.7947
Ri536	GND_h27	GND	    3.6133
Ri537	GND_h28	GND	    3.4320
Ri538	GND_h29	GND	    3.2507
Ri539	GND_h30	GND	    3.0907
Ri540	GND_h31	GND	    2.9093
Ri541	GND_h32	GND	    2.6480
Ri542	GND_h33	GND	    2.4667
Ri543	GND_h34	GND	    2.2853
Ri544	GND_h35	GND	    2.0240
Ri545	GND_h36	GND	    1.8427
Ri546	GND_h37	GND	    1.6613
Ri547	GND_h38	GND	    1.4800
Ri548	GND_h39	GND	    1.2987
Ri549	GND_h40	GND	    1.1173
Ri550	GND_h41	GND	    0.9360
Ri551	GND_h42	GND	    0.7760
Ri552	GND_h43	GND	    0.5947
Ri553	GND_h44	GND	    0.3333
Ri554	GND_h45	GND	    0.1520
Ri555	GND	GND_h46	2.933E-02
Ri556	GND	GND_h47	    0.2907
Ri557	GND	GND_h48	    0.4720
Ri558	GND	GND_h49	    0.6533
Ri559	GND	GND_h50	    0.8347
Ri560	GND	GND_h51	    1.0160
Ri561	GND	GND_h52	    1.1973
Ri562	GND	GND_h53	    1.3787
Ri563	GND	GND_h54	    1.5387
Ri564	GND	GND_h55	    1.7200
Ri565	GND	GND_h56	    1.9813
Ri566	GND	GND_h57	    2.1627
Ri567	GND	GND_h58	    2.3440
Ri568	GND	GND_h59	    2.6053
Ri569	GND	GND_h60	    2.7867
Ri570	GND	GND_h61	    2.9680
Ri571	GND	GND_h62	    3.1493
Ri572	GND	GND_h63	    3.3307
Ri573	GND	GND_h64	    3.5120
Ri574	GND	GND_h65	    3.6933
Ri575	GND	GND_h66	    3.8533
Ri576	GND	GND_h67	    4.0347
Ri577	GND	GND_h68	    4.2960
Ri578	GND	GND_h69	    4.4773
Ri579	GND	GND_h70	    4.6587
Ri580	GND	GND_h71	    4.9200
Ri581	GND	GND_h72	    5.1013
Ri582	GND	GND_h73	    5.2827
Ri583	GND	GND_h74	    5.4640
Ri584	GND	GND_h75	    5.6453
Ri585	GND	GND_h76	    5.8267
Ri586	GND	GND_h77	    6.0080
Ri587	GND	GND_h78	    6.1680
Ri588	GND	GND_h79	    6.3493
Ri589	GND	GND_h80	    6.6107
Ri590	GND	GND_h81	    6.7920
Ri591	GND	GND_h82	    6.9733
Ri592	GND	GND_h83	    7.2347
Ri593	GND	GND_h84	    7.4160
Ri594	GND	GND_h85	    7.5973
Ri595	GND	GND_h86	    7.7787
Ri596	GND	GND_h87	    7.9600
Ri597	GND	GND_h88	    8.1413
Ri598	GND	GND_h89	    8.3227
Ri599	GND	GND_h90	    8.4827
Ri600	GND	GND_h91	    8.6640
Ri601	GND_h92	GND	    8.9253
Ri602	GND	GND_h93	    9.1067
Ri603	GND_h93	GND_h94	    0.1813
Ri604	GND	GND_h95	   15.3631
Ri605	GND	GND_h96	   15.3631
Ri606	GND	GND_h97	   15.3631
Ri607	GND	GND_h98	   15.3631
Ri608	GND	GND_h99	   15.3631
Ri609	GND	GND_h100	   15.5021
Ri610	GND	GND_h101	   15.5021
Ri611	GND	GND_h102	   15.5021
Ri612	GND	GND_h103	   15.5021
Ri613	GND	GND_h104	   15.5021
Ri614	GND	GND_h105	   15.5021
Ri615	GND	GND_h106	   15.5021
Ri616	GND	GND_h107	   15.5021
Ri617	GND	GND_h108	   15.5021
Ri618	GND	GND_h109	   15.5021
Ri619	GND	GND_h110	   15.5021
Ri620	GND	GND_h111	   15.5021
Ri621	GND	GND_h112	   15.5021
Ri622	GND_h46	GND_h113	   15.5067
Ri623	GND_h47	GND_h114	   15.5067
Ri624	GND_h51	GND_h115	   15.5067
Ri625	GND_h55	GND_h116	   15.5067
Ri626	GND_h58	GND_h117	   15.5067
Ri627	GND_h59	GND_h118	   15.5067
Ri628	GND_h63	GND_h119	   15.5067
Ri629	GND_h67	GND_h120	   15.5067
Ri630	GND_h70	GND_h121	   15.5067
Ri631	GND_h71	GND_h122	   15.5067
Ri632	GND_h75	GND_h123	   15.5067
Ri633	GND_h79	GND_h124	   15.5067
Ri634	GND_h82	GND_h125	   15.5067
Ri635	GND_h83	GND_h126	   15.5067
Ri636	GND_h87	GND_h127	   15.5067
Ri637	GND_h91	GND_h128	   15.5067
Ri638	GND_h129	GND	    9.4693
Ri639	GND	GND_h130	    9.7307
Ri640	GND_h130	GND_h131	    0.1813
Ri641	GND_h131	GND_h132	    0.1813
Ri642	GND_h132	GND_h133	    0.1813
Ri643	GND_h133	GND_h134	    0.1813
Ri644	GND_h134	GND	5.260E-03
Ri645	GND	GND_h135	   15.4319
Ri646	GND_h94	GND_h136	   15.4865
Ri647	GND_h2	GND_h3	    0.8824
Ri648	GND_h2	GND_h4	    1.6667
Ri649	GND_h2	GND_h5	    1.6667
Ri650	GND_h2	GND_h6	   15.0000
Ri651	GND_h2	GND_h7	   15.0000
Ri652	GND_h2	GND_h8	   15.0000
Ri653	GND_h2	GND_h9	   15.0000
Ri654	GND_h2	GND_h10	   15.0000
Ri655	GND_h2	GND_h11	   15.0000
Ri656	GND_h2	GND_h12	   15.0000
Ri657	GND_h2	GND_h13	   15.0000
Ri658	GND_h2	GND_h14	   15.0000
Ri659	GND_h2	GND_h15	   15.0000
Ri660	GND_h2	GND_h16	   15.0000
Ri661	GND_h2	GND_h17	   15.0000
Ri662	GND_h2	GND_h18	   15.0000
Ri663	GND_h2	GND_h19	   15.0000
Ri664	GND_h2	GND_h20	   15.0000
Ri665	GND_h2	GND_h21	   15.0000
Ri666	GND_h2	GND_h22	   15.0000
Ri667	GND_h2	GND_h23	   15.0000
Ri668	GND_h2	GND_h24	   15.0000
Ri669	GND_h2	GND_h25	   15.0000
Ri670	GND_h2	GND_h26	   15.0000
Ri671	GND_h2	GND_h27	   15.0000
Ri672	GND_h2	GND_h28	   15.0000
Ri673	GND_h2	GND_h29	   15.0000
Ri674	GND_h2	GND_h30	   15.0000
Ri675	GND_h2	GND_h31	   15.0000
Ri676	GND_h2	GND_h32	   15.0000
Ri677	GND_h2	GND_h33	   15.0000
Ri678	GND_h2	GND_h34	   15.0000
Ri679	GND_h2	GND_h35	   15.0000
Ri680	GND_h2	GND_h36	   15.0000
Ri681	GND_h2	GND_h37	   15.0000
Ri682	GND_h2	GND_h38	   15.0000
Ri683	GND_h2	GND_h39	   15.0000
Ri684	GND_h2	GND_h40	   15.0000
Ri685	GND_h2	GND_h41	   15.0000
Ri686	GND_h2	GND_h42	   15.0000
Ri687	GND_h2	GND_h43	   15.0000
Ri688	GND_h2	GND_h44	   15.0000
Ri689	GND_h2	GND_h45	   15.0000
Ri690	GND_h2	GND_h46	   15.0000
Ri691	GND_h2	GND_h47	   15.0000
Ri692	GND_h2	GND_h48	   15.0000
Ri693	GND_h2	GND_h49	   15.0000
Ri694	GND_h2	GND_h50	   15.0000
Ri695	GND_h2	GND_h51	   15.0000
Ri696	GND_h2	GND_h52	   15.0000
Ri697	GND_h2	GND_h53	   15.0000
Ri698	GND_h2	GND_h54	   15.0000
Ri699	GND_h2	GND_h55	   15.0000
Ri700	GND_h2	GND_h56	   15.0000
Ri701	GND_h2	GND_h57	   15.0000
Ri702	GND_h2	GND_h58	   15.0000
Ri703	GND_h2	GND_h59	   15.0000
Ri704	GND_h2	GND_h60	   15.0000
Ri705	GND_h2	GND_h61	   15.0000
Ri706	GND_h2	GND_h62	   15.0000
Ri707	GND_h2	GND_h63	   15.0000
Ri708	GND_h2	GND_h64	   15.0000
Ri709	GND_h2	GND_h65	   15.0000
Ri710	GND_h2	GND_h66	   15.0000
Ri711	GND_h2	GND_h67	   15.0000
Ri712	GND_h2	GND_h68	   15.0000
Ri713	GND_h2	GND_h69	   15.0000
Ri714	GND_h2	GND_h70	   15.0000
Ri715	GND_h2	GND_h71	   15.0000
Ri716	GND_h2	GND_h72	   15.0000
Ri717	GND_h2	GND_h73	   15.0000
Ri718	GND_h2	GND_h74	   15.0000
Ri719	GND_h2	GND_h75	   15.0000
Ri720	GND_h2	GND_h76	   15.0000
Ri721	GND_h2	GND_h77	   15.0000
Ri722	GND_h2	GND_h78	   15.0000
Ri723	GND_h2	GND_h79	   15.0000
Ri724	GND_h2	GND_h80	   15.0000
Ri725	GND_h2	GND_h81	   15.0000
Ri726	GND_h2	GND_h82	   15.0000
Ri727	GND_h2	GND_h83	   15.0000
Ri728	GND_h2	GND_h84	   15.0000
Ri729	GND_h2	GND_h85	   15.0000
Ri730	GND_h2	GND_h86	   15.0000
Ri731	GND_h2	GND_h87	   15.0000
Ri732	GND_h2	GND_h88	   15.0000
Ri733	GND_h2	GND_h89	   15.0000
Ri734	GND_h2	GND_h90	   15.0000
Ri735	GND_h2	GND_h91	   15.0000
Ri736	GND_h2	GND_h92	   15.0000
Ri737	GND_h2	GND_h93	   15.0000
Ri738	GND_h2	GND_h94	   15.0000
Ri739	GND_h2	GND_h129	   15.0000
Ri740	GND_h2	GND_h130	   15.0000
Ri741	GND_h2	GND_h131	   15.0000
Ri742	GND_h2	GND_h132	   15.0000
Ri743	GND_h2	GND_h133	   15.0000
Ri744	GND_h2	GND_h134	   15.0000
Rh1	avC13	avC13_h4	    1.4000
Rh2	avI1/avC8_h6	avI1/avC8_h4	    0.6800
Rh3	avI1/avC8_h4	avI1/avC8_h2	    0.2720
Rh4	RST_h1	RST_h4	    1.4000
Rh5	avI1/avC9_h6	avI1/avC9_h2	    2.2000
Rh6	CLK_h12	CLK_h11	    1.0000
Rh7	CLK_h11	CLK_h4	    0.4800
Rh8	CLK_h4	CLK_h1	    0.5440
Rh9	avC1_1_h13	avC1_1_h14	    0.5280
Rh10	avC1_1_h14	avC1_1_h4	    0.8160
Rh11	avC1_1_h4	avC1_1_h2	    0.1960
Rh12	avC1_1_h7	avC1_1_h14	    1.4000
Rh13	Q0_h5	Q0_h8	    1.6400
Rh14	Q0_h8	Q0_h1	    0.2280
Rh16	RST_h12	RST_h9	    1.4000
Rh17	avI5/avC8_h6	avI5/avC8_h4	    0.9520
Rh18	avI5/avC8_h4	avI5/avC8_h2	    0.2720
Rh19	avI5/avC9_h8	avI5/avC9_h3	    2.4720
Rh20	CLK_h25	CLK_h21	    0.9360
Rh21	CLK_h21	CLK_h27	    0.2560
Rh22	CLK_h27	CLK_h18	    0.2880
Rh23	CLK_h18	CLK_h15	    0.8160
Rh24	avC1_5_h11	avC1_5_h12	    0.5280
Rh25	avC1_5_h12	avC1_5_h2	    0.7400
Rh26	avC1_5_h5	avC1_5_h12	    1.4000
Rh27	Q1_h5	Q1_h8	    1.6320
Rh28	Q1_h8	Q1_h1	    0.2360
Rh30	RST_h20	RST_h17	    1.4000
Rh31	avI6/avC8_h6	avI6/avC8_h4	    0.9520
Rh32	avI6/avC8_h4	avI6/avC8_h2	    0.2720
Rh33	avI6/avC9_h8	avI6/avC9_h3	    2.4720
Rh34	CLK_h40	CLK_h36	    0.9360
Rh35	CLK_h36	CLK_h42	    0.2560
Rh36	CLK_h42	CLK_h33	    0.2880
Rh37	CLK_h33	CLK_h30	    0.8160
Rh38	avC1_6_h11	avC1_6_h12	    0.5280
Rh39	avC1_6_h12	avC1_6_h2	    0.7400
Rh40	avC1_6_h5	avC1_6_h12	    1.4000
Rh41	Q2_h5	Q2_h8	    1.6320
Rh42	Q2_h8	Q2_h1	    0.2360
Rh44	RST_h28	RST_h25	    1.4000
Rh45	avI7/avC8_h6	avI7/avC8_h4	    0.9520
Rh46	avI7/avC8_h4	avI7/avC8_h2	    0.2720
Rh47	avI7/avC9_h8	avI7/avC9_h3	    2.4720
Rh48	CLK_h55	CLK_h51	    0.9360
Rh49	CLK_h51	CLK_h57	    0.2560
Rh50	CLK_h57	CLK_h48	    0.2880
Rh51	CLK_h48	CLK_h45	    0.8160
Rh52	avC1_7_h11	avC1_7_h12	    0.5280
Rh53	avC1_7_h12	avC1_7_h2	    0.7400
Rh54	avC1_7_h5	avC1_7_h12	    1.4000
Rh55	Q3_h5	Q3_h8	    1.6320
Rh56	Q3_h8	Q3_h1	    0.2360
Rh58	RST_h36	RST_h33	    1.4000
Rh59	avI8/avC8_h6	avI8/avC8_h4	    0.9520
Rh60	avI8/avC8_h4	avI8/avC8_h2	    0.2720
Rh61	avI8/avC9_h8	avI8/avC9_h3	    2.4720
Rh62	CLK_h70	CLK_h66	    0.9360
Rh63	CLK_h66	CLK_h72	    0.2560
Rh64	CLK_h72	CLK_h63	    0.2880
Rh65	CLK_h63	CLK_h60	    0.8160
Rh66	avC1_8_h11	avC1_8_h12	    0.5280
Rh67	avC1_8_h12	avC1_8_h2	    0.7400
Rh68	avC1_8_h5	avC1_8_h12	    1.4000
Rh69	Q4_h5	Q4_h8	    1.6320
Rh70	Q4_h8	Q4_h1	    0.2360
Rh72	RST_h44	RST_h41	    1.4000
Rh73	avI9/avC8_h6	avI9/avC8_h4	    0.9520
Rh74	avI9/avC8_h4	avI9/avC8_h2	    0.2720
Rh75	avI9/avC9_h8	avI9/avC9_h3	    2.4720
Rh76	CLK_h85	CLK_h81	    0.9360
Rh77	CLK_h81	CLK_h87	    0.2560
Rh78	CLK_h87	CLK_h78	    0.2880
Rh79	CLK_h78	CLK_h75	    0.8160
Rh80	avC1_9_h11	avC1_9_h12	    0.5280
Rh81	avC1_9_h12	avC1_9_h2	    0.7400
Rh82	avC1_9_h5	avC1_9_h12	    1.4000
Rh83	Q5_h5	Q5_h8	    1.6320
Rh84	Q5_h8	Q5_h1	    0.2360
Rh86	RST_h52	RST_h49	    1.4000
Rh87	avI10/avC8_h6	avI10/avC8_h4	    0.9520
Rh88	avI10/avC8_h4	avI10/avC8_h2	    0.2720
Rh89	avI10/avC9_h8	avI10/avC9_h3	    2.4720
Rh90	CLK_h100	CLK_h96	    0.9360
Rh91	CLK_h96	CLK_h102	    0.2560
Rh92	CLK_h102	CLK_h93	    0.2880
Rh93	CLK_h93	CLK_h90	    0.8160
Rh94	avC1_10_h11	avC1_10_h12	    0.5280
Rh95	avC1_10_h12	avC1_10_h2	    0.7400
Rh96	avC1_10_h5	avC1_10_h12	    1.4000
Rh97	Q6_h5	Q6_h8	    1.6320
Rh98	Q6_h8	Q6_h1	    0.2360
Rh100	RST_h60	RST_h57	    1.4000
Rh101	avI11/avC8_h6	avI11/avC8_h4	    0.9520
Rh102	avI11/avC8_h4	avI11/avC8_h2	    0.2720
Rh103	avI11/avC9_h8	avI11/avC9_h3	    2.4720
Rh104	CLK_h116	CLK_h111	    0.9360
Rh105	CLK_h111	CLK_h118	    0.2560
Rh106	CLK_h118	CLK_h108	    0.2880
Rh107	CLK_h108	CLK_h105	    0.8160
Rh108	avC1_11_h11	avC1_11_h12	    0.5280
Rh109	avC1_11_h12	avC1_11_h2	    0.7400
Rh110	avC1_11_h5	avC1_11_h12	    1.4000
Rh111	Q7_h5	Q7_h8	    1.6320
Rh112	Q7_h8	Q7_h1	    0.2360
Rh113	avC14_h5	avC14_h6	    0.1080
Rh114	avC14_h6	avC14_h2	    0.1080
Rh115	avI2/avC6_h7	avI2/avC6_h4	    0.3240
Rh116	avI2/avC6_h4	avI2/avC6_h2	    0.3240
Rh117	Q0_h27	Q0_h22	    0.3240
Rh118	Q0_h22	Q0_h20	    0.3240
Rh121	Q5_h26	Q5_h21	    0.3240
Rh122	Q5_h21	Q5_h19	    0.3240
Rh123	avC15_h5	avC15_h6	    0.1080
Rh124	avC15_h6	avC15_h2	    0.1080
Rh125	avI3/avC6_h7	avI3/avC6_h4	    0.3240
Rh126	avI3/avC6_h4	avI3/avC6_h2	    0.3240
Rh127	Q6_h27	Q6_h22	    0.3240
Rh128	Q6_h22	Q6_h20	    0.3240
Rh131	Q7_h18	Q7_h13	    0.3240
Rh132	Q7_h13	Q7_h11	    0.3240
Rh133	avI4/avC6_h6	avI4/avC6_h4	    0.3240
Rh134	avI4/avC6_h4	avI4/avC6_h2	    0.2160
Rh135	avC13_h13	avC13_h14	    0.1080
Rh136	avC13_h14	avC13_h10	    0.1080
Rh137	avC15_h16	avC15_h14	    1.0800
Rh138	avC15_h14	avC15_h9	    1.4000
Rh139	avI4/avC10_h5	avI4/avC10_h3	    1.8320
Rh140	avI4/avC10_h3	avI4/avC10	    0.4320
Rh141	avC14_h14	avC14_h15	    0.2160
Rh142	avC14_h15	avC14_h9	    0.4320
Rh143	avI4/avC7_h8	avI4/avC7_h6	    0.2160
Rh144	avI4/avC7_h6	avI4/avC7_h2	    0.7560
Rg1	avC13_h8	avC13_h4	    1.4680
Rg2	CLK_h10	CLK_h11	    2.8560
Rg3	RST_h8	RST_h4	    1.4480
Rg4	Q0_h9	Q0_h8	    2.8600
Rg5	Q0_h13	Q0_h10	    3.1000
Rg6	RST_h16	RST_h12	    1.4480
Rg7	CLK_h29	CLK_h27	    2.8560
Rg8	Q1_h9	Q1_h8	    2.9760
Rg9	Q1_h13	Q1_h10	    3.2160
Rg10	RST_h24	RST_h20	    1.4480
Rg11	CLK_h44	CLK_h42	    2.8560
Rg12	Q2_h9	Q2_h8	    2.9760
Rg13	Q2_h13	Q2_h10	    3.2160
Rg14	RST_h32	RST_h28	    1.4480
Rg15	CLK_h59	CLK_h57	    2.8560
Rg16	Q3_h9	Q3_h8	    2.9760
Rg17	Q3_h13	Q3_h10	    3.2160
Rg18	RST_h40	RST_h36	    1.4480
Rg19	CLK_h74	CLK_h72	    2.8560
Rg20	Q4_h9	Q4_h8	    2.9760
Rg21	Q4_h13	Q4_h10	    3.2160
Rg22	RST_h48	RST_h44	    1.4480
Rg23	CLK_h89	CLK_h87	    2.8560
Rg24	Q5_h9	Q5_h8	    2.9760
Rg25	Q5_h13	Q5_h10	    3.2160
Rg26	RST_h56	RST_h52	    1.4480
Rg27	CLK_h104	CLK_h102	    2.8560
Rg28	Q6_h9	Q6_h8	    3.0920
Rg29	Q6_h13	Q6_h10	    3.3320
Rg30	RST_h64	RST_h60	    1.4480
Rg31	CLK_h115	CLK_h118	    1.4560
Rg32	Q7_h9	Q7_h8	    2.8560
Rg33	Q0_h20	Q0_h25	    3.0800
Rg34	avC14_h7	avC14_h6	    2.8480
Rg35	Q5_h28	Q5_h26	    2.9840
Rg36	Q6_h24	Q6_h20	    2.8480
Rg37	avC15_h7	avC15_h6	    2.8680
Rg38	Q7_h20	Q7_h18	    2.8480
Rg39	avC15_h13	avC15_h14	    2.8680
Rg40	avC13_h15	avC13_h14	    2.8480
Rg41	avC14_h15	avC14_h19	    2.9640
Rf1	Q1_h13	Q1	    0.4398
Rf2	Q1	Q1_h9	    0.4400
Rf3	Q2_h13	Q2	    0.4398
Rf4	Q2	Q2_h9	    0.4400
Rf5	Q3_h13	Q3	    0.4398
Rf6	Q3	Q3_h9	    0.4400
Rf7	Q4_h13	Q4	    0.4398
Rf8	Q4	Q4_h9	    0.4400
Rf9	RST_h64	RST_h56	    3.4720
Rf10	RST_h56	RST_h48	    3.4720
Rf11	RST_h48	RST_h40	    3.4720
Rf12	RST_h40	RST	    1.1318
Rf13	RST	RST_h32	    2.3400
Rf14	RST_h32	RST_h24	    3.4720
Rf15	RST_h24	RST_h16	    3.4720
Rf16	RST_h16	RST_h8	    2.2640
Rf17	CLK_h115	CLK_h104	    4.8720
Rf18	CLK_h104	CLK_h89	    3.4720
Rf19	CLK_h89	CLK_h74	    3.4720
Rf20	CLK_h74	CLK	    1.6398
Rf21	CLK	CLK_h59	    1.8320
Rf22	CLK_h59	CLK_h44	    3.4720
Rf23	CLK_h44	CLK_h29	    3.4720
Rf24	CLK_h29	CLK_h10	    3.2800
Rf25	Q0_h25	Q0	   12.4398
Rf26	Q0	Q0_h13	   11.5520
Rf27	Q0_h13	Q0_h9	    0.8880
Rf28	Q5_h28	Q5	    4.1338
Rf29	Q5	Q5_h13	    3.2540
Rf30	Q5_h13	Q5_h9	    0.8800
Rf31	Q6_h24	Q6	    2.5598
Rf32	Q6	Q6_h13	    1.6800
Rf33	Q6_h13	Q6_h9	    0.8800
Rf34	Q7_h20	Q7	    1.2018
Rf35	Q7	Q7_h9	    1.2020
Rf36	avC15_h13	avC15_h7	    0.6480
Rf37	avC13_h15	avC13_h8	   30.0000
Rf38	avC14_h19	avC14_h7	    3.0240
C1	VDD	GND	3.010E-15
C2	CLK	GND	8.811E-16
C3	Q0	GND	4.547E-15
C4	Q1	GND	1.320E-16
C5	Q2	GND	1.320E-16
C6	Q3	GND	1.320E-16
C7	Q4	GND	1.320E-16
C8	Q5	GND	1.709E-15
C9	Q6	GND	6.888E-16
C10	Q7	GND	5.893E-16
C11	RST	GND	5.811E-16
C12	avC13	GND	1.480E-16
C13	avC1_1	GND	6.965E-17
C14	avC14	GND	1.017E-16
C15	avC15	GND	1.017E-16
C16	avC1_5	GND	7.920E-17
C17	avC1_6	GND	7.880E-17
C18	avC1_7	GND	7.880E-17
C19	avC1_8	GND	7.920E-17
C20	avC1_9	GND	7.880E-17
C21	avC1_10	GND	7.852E-17
C22	avC1_11	GND	7.925E-17
C23	avI11/avC13	GND	1.463E-17
C24	avI11/avC12	GND	1.514E-17
C25	avI11/avC11	GND	1.405E-18
C26	avI11/avC10	GND	2.488E-17
C27	avI11/avC9	GND	7.164E-17
C28	avI11/avC8	GND	3.608E-17
C29	avI10/avC11	GND	2.457E-18
C30	avI10/avC10	GND	1.180E-17
C31	avI10/avC9	GND	7.034E-17
C32	avI10/avC8	GND	2.834E-17
C33	avI9/avC11	GND	2.457E-18
C34	avI9/avC10	GND	1.180E-17
C35	avI9/avC9	GND	7.034E-17
C36	avI9/avC8	GND	2.834E-17
C37	avI8/avC11	GND	2.457E-18
C38	avI8/avC10	GND	1.180E-17
C39	avI8/avC9	GND	7.034E-17
C40	avI8/avC8	GND	2.834E-17
C41	avI7/avC11	GND	2.457E-18
C42	avI7/avC10	GND	1.180E-17
C43	avI7/avC9	GND	7.034E-17
C44	avI7/avC8	GND	2.834E-17
C45	avI6/avC11	GND	2.457E-18
C46	avI6/avC10	GND	1.180E-17
C47	avI6/avC9	GND	7.034E-17
C48	avI6/avC8	GND	2.834E-17
C49	avI5/avC11	GND	2.457E-18
C50	avI5/avC10	GND	1.180E-17
C51	avI5/avC9	GND	7.034E-17
C52	avI5/avC8	GND	2.834E-17
C53	avI4/avC10	GND	1.292E-16
C54	avI4/avC8	GND	1.737E-17
C55	avI4/avC7	GND	1.124E-16
C56	avI4/avC6	GND	8.435E-17
C57	avI3/avC6	GND	1.357E-16
C58	avI2/avC6	GND	1.331E-16
C59	avI1/avC13	GND	1.601E-17
C60	avI1/avC11	GND	3.065E-18
C61	avI1/avC10	GND	2.501E-17
C62	avI1/avC9	GND	8.943E-17
C63	avI1/avC8	GND	2.166E-17
C64	CLK_h3	GND	4.297E-17
C65	avC13_h5	GND	4.809E-17
C66	CLK_h7	GND	5.069E-17
C67	avC1_1_h5	GND	8.188E-17
C68	RST_h5	GND	5.738E-17
C69	avI1/avC9_h8	GND	3.835E-17
C70	Q0_h3	GND	5.414E-17
C71	avC1_1_h15	GND	7.046E-17
C72	CLK_h17	GND	4.642E-17
C73	Q0_h15	GND	4.747E-17
C74	RST_h13	GND	4.825E-17
C75	CLK_h20	GND	4.621E-17
C76	avC1_5_h3	GND	7.727E-17
C77	avI5/avC9_h10	GND	5.675E-17
C78	Q1_h3	GND	5.411E-17
C79	avC1_5_h13	GND	7.022E-17
C80	CLK_h32	GND	4.642E-17
C81	Q1_h15	GND	4.707E-17
C82	RST_h21	GND	4.817E-17
C83	CLK_h35	GND	4.621E-17
C84	avC1_6_h3	GND	7.727E-17
C85	avI6/avC9_h10	GND	5.675E-17
C86	Q2_h3	GND	5.411E-17
C87	avC1_6_h13	GND	7.022E-17
C88	CLK_h47	GND	4.642E-17
C89	Q2_h15	GND	4.707E-17
C90	RST_h29	GND	4.817E-17
C91	CLK_h50	GND	4.621E-17
C92	avC1_7_h3	GND	7.727E-17
C93	avI7/avC9_h10	GND	5.675E-17
C94	Q3_h3	GND	5.411E-17
C95	avC1_7_h13	GND	7.022E-17
C96	CLK_h62	GND	4.642E-17
C97	Q3_h15	GND	4.707E-17
C98	RST_h37	GND	4.817E-17
C99	CLK_h65	GND	4.621E-17
C100	avC1_8_h3	GND	7.727E-17
C101	avI8/avC9_h10	GND	5.675E-17
C102	Q4_h3	GND	5.411E-17
C103	avC1_8_h13	GND	7.022E-17
C104	CLK_h77	GND	4.642E-17
C105	Q4_h15	GND	4.707E-17
C106	RST_h45	GND	4.817E-17
C107	CLK_h80	GND	4.621E-17
C108	avC1_9_h3	GND	7.727E-17
C109	avI9/avC9_h10	GND	5.675E-17
C110	Q5_h3	GND	5.411E-17
C111	avC1_9_h13	GND	7.022E-17
C112	CLK_h92	GND	4.642E-17
C113	Q5_h15	GND	4.707E-17
C114	RST_h53	GND	4.817E-17
C115	CLK_h95	GND	4.621E-17
C116	avC1_10_h3	GND	7.736E-17
C117	avI10/avC9_h10	GND	5.675E-17
C118	Q6_h3	GND	5.362E-17
C119	avC1_10_h13	GND	6.968E-17
C120	CLK_h107	GND	4.579E-17
C121	Q6_h15	GND	4.567E-17
C122	RST_h61	GND	4.941E-17
C123	CLK_h110	GND	4.442E-17
C124	avC1_11_h3	GND	7.225E-17
C125	avI11/avC9_h10	GND	5.673E-17
C126	Q7_h3	GND	5.397E-17
C127	avC1_11_h13	GND	7.461E-17
C128	Q0_h21	GND	6.350E-17
C129	Q5_h22	GND	6.660E-17
C130	Q0_h28	GND	5.183E-17
C131	Q6_h21	GND	6.132E-17
C132	Q7_h14	GND	6.727E-17
C133	Q6_h28	GND	5.188E-17
C134	avC15_h11	GND	5.754E-17
C135	avI4/avC6_h7	GND	6.474E-17
C136	avI4/avC7_h3	GND	6.311E-17
C137	avC14_h10	GND	5.729E-17
C138	avC15_h17	GND	6.874E-17
C139	avC14_h16	GND	6.493E-17
C140	avC13_h7	GND	4.733E-17
C141	CLK_h9	GND	5.770E-17
C142	avI1/avC8_h7	GND	4.503E-17
C143	RST_h7	GND	3.474E-17
C144	avI1/avC9_h9	GND	5.373E-17
C145	CLK_h14	GND	4.666E-17
C146	avC1_1_h16	GND	4.673E-17
C147	Q0_h17	GND	3.771E-17
C148	RST_h15	GND	3.660E-17
C149	avI5/avC8_h7	GND	4.720E-17
C150	CLK_h24	GND	4.802E-17
C151	avI5/avC9_h11	GND	4.642E-17
C152	CLK_h28	GND	4.632E-17
C153	avC1_5_h14	GND	4.731E-17
C154	Q1_h17	GND	3.771E-17
C155	RST_h23	GND	3.659E-17
C156	avI6/avC8_h7	GND	4.718E-17
C157	CLK_h39	GND	4.802E-17
C158	avI6/avC9_h11	GND	4.642E-17
C159	CLK_h43	GND	4.632E-17
C160	avC1_6_h14	GND	4.731E-17
C161	Q2_h17	GND	3.771E-17
C162	RST_h31	GND	3.659E-17
C163	avI7/avC8_h7	GND	4.718E-17
C164	CLK_h54	GND	4.802E-17
C165	avI7/avC9_h11	GND	4.619E-17
C166	CLK_h58	GND	4.635E-17
C167	avC1_7_h14	GND	4.731E-17
C168	Q3_h17	GND	3.771E-17
C169	RST_h39	GND	3.659E-17
C170	avI8/avC8_h7	GND	4.718E-17
C171	CLK_h69	GND	4.802E-17
C172	avI8/avC9_h11	GND	4.642E-17
C173	CLK_h73	GND	4.632E-17
C174	avC1_8_h14	GND	4.731E-17
C175	Q4_h17	GND	3.771E-17
C176	RST_h47	GND	3.659E-17
C177	avI9/avC8_h7	GND	4.718E-17
C178	CLK_h84	GND	4.802E-17
C179	avI9/avC9_h11	GND	4.642E-17
C180	CLK_h88	GND	4.632E-17
C181	avC1_9_h14	GND	4.731E-17
C182	Q5_h17	GND	3.771E-17
C183	RST_h55	GND	3.659E-17
C184	avI10/avC8_h7	GND	4.718E-17
C185	CLK_h99	GND	4.802E-17
C186	avI10/avC9_h11	GND	4.642E-17
C187	CLK_h103	GND	4.632E-17
C188	avC1_10_h14	GND	4.731E-17
C189	Q6_h17	GND	3.773E-17
C190	RST_h63	GND	3.660E-17
C191	avI11/avC8_h7	GND	4.959E-17
C192	CLK_h114	GND	4.762E-17
C193	avI11/avC9_h11	GND	4.757E-17
C194	CLK_h119	GND	4.706E-17
C195	avC1_11_h14	GND	4.418E-17
C196	avI2/avC6_h5	GND	4.557E-17
C197	Q5_h23	GND	5.971E-17
C198	Q0_h29	GND	6.045E-17
C199	avI3/avC6_h5	GND	4.602E-17
C200	Q7_h15	GND	5.930E-17
C201	Q6_h29	GND	5.849E-17
C202	avC15_h12	GND	5.512E-17
C203	avI4/avC6_h8	GND	5.544E-17
C204	avI4/avC7_h4	GND	5.208E-17
C205	avC14_h11	GND	5.747E-17
C206	avC15_h18	GND	5.861E-17
C207	avC14_h18	GND	5.870E-17
C208	avC13_h4	GND	1.971E-17
C209	CLK_h11	GND	1.879E-16
C210	Q0_h8	GND	8.227E-17
C211	RST_h12	GND	5.340E-17
C212	CLK_h27	GND	5.834E-17
C213	Q1_h8	GND	9.162E-17
C214	RST_h20	GND	5.340E-17
C215	CLK_h42	GND	5.819E-17
C216	Q2_h8	GND	9.162E-17
C217	RST_h28	GND	5.340E-17
C218	CLK_h57	GND	5.819E-17
C219	Q3_h8	GND	9.059E-17
C220	RST_h36	GND	5.340E-17
C221	CLK_h72	GND	5.834E-17
C222	Q4_h8	GND	9.162E-17
C223	RST_h44	GND	5.340E-17
C224	CLK_h87	GND	5.819E-17
C225	Q5_h8	GND	9.078E-17
C226	RST_h52	GND	5.340E-17
C227	CLK_h102	GND	5.846E-17
C228	Q6_h8	GND	9.995E-17
C229	RST_h60	GND	5.384E-17
C230	CLK_h118	GND	5.835E-17
C231	Q7_h8	GND	5.409E-17
C232	avC14_h6	GND	4.156E-17
C233	avC15_h6	GND	7.229E-17
C234	avC15_h14	GND	2.664E-16
C235	avC13_h14	GND	3.860E-17
C236	avC14_h15	GND	1.297E-16
C237	CLK_h2	GND	1.122E-16
C238	avC13_h2	GND	1.630E-16
C239	CLK_h5	GND	7.727E-17
C240	avI1/avC8_h5	GND	7.047E-17
C241	RST_h2	GND	1.519E-16
C242	avI1/avC9_h7	GND	9.617E-17
C243	CLK_h13	GND	1.054E-16
C244	Q0_h2	GND	9.247E-17
C245	avC1_1_h12	GND	9.327E-17
C246	CLK_h16	GND	1.164E-16
C247	Q0_h11	GND	1.514E-16
C248	RST_h10	GND	1.177E-16
C249	CLK_h19	GND	7.717E-17
C250	avI5/avC8_h5	GND	7.082E-17
C251	CLK_h22	GND	8.524E-17
C252	avI5/avC9_h9	GND	1.009E-16
C253	CLK_h26	GND	1.095E-16
C254	Q1_h2	GND	9.565E-17
C255	avC1_5_h10	GND	9.260E-17
C256	CLK_h31	GND	1.143E-16
C257	Q1_h11	GND	1.487E-16
C258	RST_h18	GND	1.162E-16
C259	CLK_h34	GND	7.742E-17
C260	avI6/avC8_h5	GND	7.076E-17
C261	CLK_h37	GND	8.524E-17
C262	avI6/avC9_h9	GND	1.008E-16
C263	CLK_h41	GND	1.095E-16
C264	Q2_h2	GND	9.565E-17
C265	avC1_6_h10	GND	9.260E-17
C266	CLK_h46	GND	1.143E-16
C267	Q2_h11	GND	1.487E-16
C268	RST_h26	GND	1.162E-16
C269	CLK_h49	GND	7.742E-17
C270	avI7/avC8_h5	GND	7.076E-17
C271	CLK_h52	GND	8.524E-17
C272	avI7/avC9_h9	GND	1.007E-16
C273	CLK_h56	GND	1.095E-16
C274	Q3_h2	GND	9.565E-17
C275	avC1_7_h10	GND	9.250E-17
C276	CLK_h61	GND	1.143E-16
C277	Q3_h11	GND	1.487E-16
C278	RST_h34	GND	1.163E-16
C279	CLK_h64	GND	7.742E-17
C280	avI8/avC8_h5	GND	7.082E-17
C281	CLK_h67	GND	8.524E-17
C282	avI8/avC9_h9	GND	1.009E-16
C283	CLK_h71	GND	1.095E-16
C284	Q4_h2	GND	9.565E-17
C285	avC1_8_h10	GND	9.260E-17
C286	CLK_h76	GND	1.143E-16
C287	Q4_h11	GND	1.487E-16
C288	RST_h42	GND	1.162E-16
C289	CLK_h79	GND	7.742E-17
C290	avI9/avC8_h5	GND	7.076E-17
C291	CLK_h82	GND	8.524E-17
C292	avI9/avC9_h9	GND	1.008E-16
C293	CLK_h86	GND	1.095E-16
C294	Q5_h2	GND	9.565E-17
C295	avC1_9_h10	GND	9.250E-17
C296	CLK_h91	GND	1.143E-16
C297	Q5_h11	GND	1.486E-16
C298	RST_h50	GND	1.118E-16
C299	CLK_h94	GND	7.599E-17
C300	avI10/avC8_h5	GND	7.073E-17
C301	CLK_h97	GND	8.834E-17
C302	avI10/avC9_h9	GND	9.935E-17
C303	CLK_h101	GND	1.055E-16
C304	Q6_h2	GND	9.223E-17
C305	avC1_10_h10	GND	9.248E-17
C306	CLK_h106	GND	1.119E-16
C307	Q6_h11	GND	1.487E-16
C308	RST_h58	GND	1.112E-16
C309	CLK_h109	GND	7.369E-17
C310	avI11/avC8_h5	GND	7.073E-17
C311	CLK_h112	GND	8.770E-17
C312	avI11/avC9_h9	GND	9.895E-17
C313	CLK_h117	GND	1.047E-16
C314	Q7_h2	GND	9.028E-17
C315	avC1_11_h10	GND	8.843E-17
C316	Q0_h18	GND	1.466E-16
C317	avI2/avC6_h3	GND	1.394E-16
C318	Q5_h20	GND	1.265E-16
C319	Q0_h26	GND	1.790E-16
C320	Q6_h18	GND	1.511E-16
C321	avI3/avC6_h3	GND	1.444E-16
C322	Q7_h12	GND	1.270E-16
C323	Q6_h26	GND	1.827E-16
C324	avC15_h8	GND	6.759E-17
C325	avI4/avC6_h5	GND	1.024E-16
C326	avC14_h8	GND	9.587E-17
C327	avC15_h15	GND	5.478E-17
C328	avC14_h12	GND	1.375E-16
C329	avC13_h8	GND	7.374E-15
C330	CLK_h10	GND	5.683E-16
C331	RST_h8	GND	4.584E-16
C332	Q0_h9	GND	1.886E-16
C333	Q0_h13	GND	2.125E-15
C334	RST_h16	GND	1.029E-15
C335	CLK_h29	GND	1.715E-15
C336	Q1_h9	GND	1.270E-16
C337	Q1_h13	GND	1.530E-16
C338	RST_h24	GND	1.231E-15
C339	CLK_h44	GND	1.767E-15
C340	Q2_h9	GND	1.270E-16
C341	Q2_h13	GND	1.530E-16
C342	RST_h32	GND	1.042E-15
C343	CLK_h59	GND	1.353E-15
C344	Q3_h9	GND	1.270E-16
C345	Q3_h13	GND	1.526E-16
C346	RST_h40	GND	8.387E-16
C347	CLK_h74	GND	1.300E-15
C348	Q4_h9	GND	1.270E-16
C349	Q4_h13	GND	1.530E-16
C350	RST_h48	GND	1.231E-15
C351	CLK_h89	GND	1.767E-15
C352	Q5_h9	GND	1.960E-16
C353	Q5_h13	GND	6.779E-16
C354	RST_h56	GND	1.232E-15
C355	CLK_h104	GND	1.770E-15
C356	Q6_h9	GND	1.992E-16
C357	Q6_h13	GND	4.751E-16
C358	RST_h64	GND	6.805E-16
C359	CLK_h115	GND	9.546E-16
C360	Q7_h9	GND	3.734E-16
C361	Q0_h25	GND	3.046E-15
C362	avC14_h7	GND	7.784E-16
C363	Q5_h28	GND	1.095E-15
C364	Q6_h24	GND	4.539E-16
C365	avC15_h7	GND	1.372E-16
C366	Q7_h20	GND	3.864E-16
C367	avC15_h13	GND	1.396E-16
C368	avC13_h15	GND	6.375E-15
C369	avC14_h19	GND	3.399E-16
C370	avI1/avC8_h2	GND	1.212E-16
C371	CLK_h1	GND	1.770E-16
C372	avI1/avC8_h4	GND	2.579E-16
C373	CLK_h4	GND	1.814E-16
C374	avI1/avC8_h6	GND	1.766E-16
C375	avI1/avC9_h2	GND	2.473E-16
C376	avC1_1_h2	GND	9.436E-17
C377	avC1_1_h4	GND	2.738E-16
C378	RST_h1	GND	1.439E-16
C379	avI1/avC9_h6	GND	1.783E-16
C380	CLK_h12	GND	2.094E-16
C381	avC1_1_h7	GND	2.519E-16
C382	Q0_h1	GND	1.082E-16
C383	avC1_1_h13	GND	1.596E-16
C384	Q0_h5	GND	2.703E-17
C385	avI5/avC8_h2	GND	1.301E-16
C386	CLK_h15	GND	2.067E-16
C387	avI5/avC8_h4	GND	3.049E-16
C388	Q0_h10	GND	2.014E-16
C389	RST_h9	GND	1.079E-16
C390	CLK_h18	GND	2.276E-16
C391	avI5/avC8_h6	GND	2.407E-16
C392	CLK_h21	GND	1.555E-16
C393	avC1_5_h2	GND	1.932E-16
C394	avI5/avC9_h8	GND	2.116E-16
C395	CLK_h25	GND	1.965E-16
C396	avC1_5_h5	GND	2.435E-16
C397	Q1_h1	GND	1.091E-16
C398	avC1_5_h11	GND	1.591E-16
C399	Q1_h5	GND	2.902E-17
C400	avI6/avC8_h2	GND	1.310E-16
C401	CLK_h30	GND	2.069E-16
C402	avI6/avC8_h4	GND	3.199E-16
C403	Q1_h10	GND	2.108E-16
C404	RST_h17	GND	1.079E-16
C405	CLK_h33	GND	2.263E-16
C406	avI6/avC8_h6	GND	2.412E-16
C407	CLK_h36	GND	1.540E-16
C408	avC1_6_h2	GND	1.932E-16
C409	avI6/avC9_h8	GND	2.116E-16
C410	CLK_h40	GND	1.951E-16
C411	avC1_6_h5	GND	2.384E-16
C412	Q2_h1	GND	1.030E-16
C413	avC1_6_h11	GND	1.591E-16
C414	Q2_h5	GND	2.902E-17
C415	avI7/avC8_h2	GND	1.310E-16
C416	CLK_h45	GND	2.069E-16
C417	avI7/avC8_h4	GND	3.199E-16
C418	Q2_h10	GND	2.108E-16
C419	RST_h25	GND	1.079E-16
C420	CLK_h48	GND	2.263E-16
C421	avI7/avC8_h6	GND	2.412E-16
C422	CLK_h51	GND	1.540E-16
C423	avC1_7_h2	GND	1.932E-16
C424	avI7/avC9_h8	GND	2.116E-16
C425	CLK_h55	GND	1.940E-16
C426	avC1_7_h5	GND	2.433E-16
C427	Q3_h1	GND	1.075E-16
C428	avC1_7_h11	GND	1.590E-16
C429	Q3_h5	GND	2.826E-17
C430	avI8/avC8_h2	GND	1.309E-16
C431	CLK_h60	GND	2.060E-16
C432	avI8/avC8_h4	GND	3.197E-16
C433	Q3_h10	GND	2.108E-16
C434	RST_h33	GND	1.079E-16
C435	CLK_h63	GND	2.276E-16
C436	avI8/avC8_h6	GND	2.412E-16
C437	CLK_h66	GND	1.555E-16
C438	avC1_8_h2	GND	1.932E-16
C439	avI8/avC9_h8	GND	2.116E-16
C440	CLK_h70	GND	1.965E-16
C441	avC1_8_h5	GND	2.435E-16
C442	Q4_h1	GND	1.091E-16
C443	avC1_8_h11	GND	1.591E-16
C444	Q4_h5	GND	2.902E-17
C445	avI9/avC8_h2	GND	1.310E-16
C446	CLK_h75	GND	2.069E-16
C447	avI9/avC8_h4	GND	3.199E-16
C448	Q4_h10	GND	2.108E-16
C449	RST_h41	GND	1.079E-16
C450	CLK_h78	GND	2.263E-16
C451	avI9/avC8_h6	GND	2.412E-16
C452	CLK_h81	GND	1.540E-16
C453	avC1_9_h2	GND	1.932E-16
C454	avI9/avC9_h8	GND	2.116E-16
C455	CLK_h85	GND	1.951E-16
C456	avC1_9_h5	GND	2.435E-16
C457	Q5_h1	GND	1.083E-16
C458	avC1_9_h11	GND	1.591E-16
C459	Q5_h5	GND	2.787E-17
C460	avI10/avC8_h2	GND	1.308E-16
C461	CLK_h90	GND	2.058E-16
C462	avI10/avC8_h4	GND	3.118E-16
C463	Q5_h10	GND	2.108E-16
C464	RST_h49	GND	1.079E-16
C465	CLK_h93	GND	2.264E-16
C466	avI10/avC8_h6	GND	2.424E-16
C467	CLK_h96	GND	1.546E-16
C468	avC1_10_h2	GND	1.907E-16
C469	avI10/avC9_h8	GND	2.158E-16
C470	CLK_h100	GND	1.949E-16
C471	avC1_10_h5	GND	2.386E-16
C472	Q6_h1	GND	1.076E-16
C473	avC1_10_h11	GND	1.489E-16
C474	Q6_h5	GND	2.943E-17
C475	avI11/avC8_h2	GND	1.310E-16
C476	CLK_h105	GND	2.058E-16
C477	avI11/avC8_h4	GND	3.066E-16
C478	Q6_h10	GND	2.253E-16
C479	RST_h57	GND	1.079E-16
C480	CLK_h108	GND	2.240E-16
C481	avI11/avC8_h6	GND	2.402E-16
C482	CLK_h111	GND	1.761E-16
C483	avC1_11_h2	GND	1.921E-16
C484	avI11/avC9_h8	GND	2.207E-16
C485	CLK_h116	GND	2.078E-16
C486	avC1_11_h5	GND	2.427E-16
C487	Q7_h1	GND	1.056E-16
C488	avC1_11_h11	GND	1.484E-16
C489	Q7_h5	GND	3.474E-17
C490	avI2/avC6_h2	GND	1.612E-16
C491	Q0_h20	GND	1.514E-16
C492	Q5_h19	GND	1.781E-16
C493	avI2/avC6_h4	GND	1.952E-16
C494	avC14_h2	GND	1.794E-16
C495	Q0_h22	GND	1.319E-16
C496	Q5_h21	GND	2.514E-16
C497	avI2/avC6_h7	GND	1.409E-16
C498	avC14_h5	GND	1.720E-16
C499	Q0_h27	GND	1.555E-16
C500	Q5_h26	GND	1.219E-16
C501	avI3/avC6_h2	GND	1.637E-16
C502	Q6_h20	GND	1.104E-16
C503	Q7_h11	GND	1.690E-16
C504	avI3/avC6_h4	GND	1.964E-16
C505	avC15_h2	GND	1.843E-16
C506	Q6_h22	GND	1.260E-16
C507	Q7_h13	GND	2.318E-16
C508	avI3/avC6_h7	GND	1.390E-16
C509	avC15_h5	GND	1.703E-16
C510	Q6_h27	GND	1.452E-16
C511	Q7_h18	GND	6.660E-17
C512	avI4/avC6_h2	GND	1.530E-16
C513	avC15_h9	GND	1.003E-16
C514	avI4/avC6_h4	GND	1.331E-16
C515	avI4/avC6_h6	GND	1.329E-16
C516	avC13_h10	GND	1.745E-16
C517	avI4/avC7_h2	GND	2.726E-16
C518	avC13_h13	GND	4.455E-17
C519	avI4/avC10_h3	GND	2.031E-16
C520	avC14_h9	GND	2.058E-16
C521	avC15_h16	GND	3.878E-16
C522	avI4/avC10_h5	GND	1.690E-16
C523	avI4/avC7_h6	GND	2.301E-16
C524	avC14_h14	GND	8.330E-17
C525	avI4/avC7_h8	GND	7.943E-17
C526	VDD_h2	GND	5.809E-15
C527	VDD_h128	GND	3.765E-17
C528	avI1/avC9_h5	GND	4.948E-17
C529	VDD_h122	GND	5.186E-17
C530	avC1_1_h10	GND	6.792E-17
C531	avC1_1_h8	GND	5.188E-17
C532	VDD_h121	GND	3.629E-17
C533	Q0_h4	GND	5.103E-17
C534	VDD_h120	GND	3.307E-17
C535	avI5/avC9_h2	GND	8.711E-19
C536	VDD_h119	GND	5.963E-17
C537	avC1_5_h8	GND	6.827E-17
C538	avC1_5_h6	GND	5.184E-17
C539	VDD_h118	GND	3.695E-17
C540	Q1_h4	GND	5.072E-17
C541	VDD_h117	GND	3.307E-17
C542	avI6/avC9_h2	GND	8.711E-19
C543	VDD_h116	GND	5.963E-17
C544	avC1_6_h8	GND	6.827E-17
C545	avC1_6_h6	GND	5.184E-17
C546	VDD_h115	GND	3.695E-17
C547	Q2_h4	GND	5.072E-17
C548	VDD_h114	GND	3.307E-17
C549	avI7/avC9_h2	GND	8.711E-19
C550	VDD_h113	GND	5.963E-17
C551	avC1_7_h8	GND	6.827E-17
C552	avC1_7_h6	GND	5.184E-17
C553	VDD_h112	GND	3.695E-17
C554	Q3_h4	GND	5.072E-17
C555	VDD_h111	GND	3.307E-17
C556	avI8/avC9_h2	GND	8.711E-19
C557	VDD_h110	GND	5.963E-17
C558	avC1_8_h8	GND	6.827E-17
C559	avC1_8_h6	GND	5.184E-17
C560	VDD_h109	GND	3.695E-17
C561	Q4_h4	GND	5.072E-17
C562	VDD_h108	GND	3.307E-17
C563	avI9/avC9_h2	GND	8.711E-19
C564	VDD_h107	GND	5.963E-17
C565	avC1_9_h8	GND	6.827E-17
C566	avC1_9_h6	GND	5.184E-17
C567	VDD_h106	GND	3.695E-17
C568	Q5_h4	GND	5.072E-17
C569	VDD_h105	GND	3.281E-17
C570	avI10/avC9_h2	GND	8.711E-19
C571	VDD_h104	GND	5.957E-17
C572	avC1_10_h8	GND	6.826E-17
C573	avC1_10_h6	GND	5.278E-17
C574	VDD_h103	GND	4.671E-17
C575	Q6_h4	GND	5.012E-17
C576	VDD_h102	GND	4.621E-17
C577	avI11/avC9_h2	GND	4.794E-18
C578	VDD_h101	GND	5.664E-17
C579	avC1_11_h8	GND	7.104E-17
C580	avC1_11_h6	GND	5.450E-17
C581	VDD_h100	GND	4.369E-17
C582	Q7_h4	GND	7.007E-17
C583	VDD_h99	GND	6.935E-17
C584	avC14_h3	GND	8.106E-17
C585	Q5_h24	GND	8.399E-17
C586	VDD_h98	GND	6.607E-17
C587	avC15_h3	GND	7.734E-17
C588	Q7_h16	GND	8.157E-17
C589	VDD_h97	GND	4.743E-17
C590	avC13_h9	GND	1.203E-16
C591	avI4/avC10_h4	GND	1.038E-18
C592	VDD_h96	GND	6.157E-17
C593	avI4/avC10_h6	GND	7.398E-19
C594	avI4/avC7_h5	GND	1.070E-16
C595	VDD_h1	GND	3.265E-17
C596	avI1/avC8_h3	GND	7.926E-17
C597	avC1_1_h3	GND	6.004E-17
C598	avC1_1_h11	GND	2.714E-17
C599	Q0_h7	GND	2.558E-17
C600	avI5/avC8_h3	GND	6.623E-17
C601	avI5/avC9_h7	GND	6.975E-17
C602	avI5/avC9_h5	GND	1.157E-16
C603	avC1_5_h9	GND	2.454E-17
C604	Q1_h7	GND	2.557E-17
C605	avI6/avC8_h3	GND	6.498E-17
C606	avI6/avC9_h7	GND	6.975E-17
C607	avI6/avC9_h5	GND	1.151E-16
C608	avC1_6_h9	GND	2.454E-17
C609	Q2_h7	GND	2.557E-17
C610	avI7/avC8_h3	GND	6.498E-17
C611	avI7/avC9_h7	GND	6.975E-17
C612	avI7/avC9_h5	GND	1.151E-16
C613	avC1_7_h9	GND	2.454E-17
C614	Q3_h7	GND	2.557E-17
C615	avI8/avC8_h3	GND	6.498E-17
C616	avI8/avC9_h7	GND	6.975E-17
C617	avI8/avC9_h5	GND	1.152E-16
C618	avC1_8_h9	GND	2.454E-17
C619	Q4_h7	GND	2.557E-17
C620	avI9/avC8_h3	GND	6.498E-17
C621	avI9/avC9_h7	GND	6.975E-17
C622	avI9/avC9_h5	GND	1.151E-16
C623	avC1_9_h9	GND	2.454E-17
C624	Q5_h7	GND	2.557E-17
C625	avI10/avC8_h3	GND	6.498E-17
C626	avI10/avC9_h7	GND	6.975E-17
C627	avI10/avC9_h5	GND	1.151E-16
C628	avC1_10_h9	GND	2.454E-17
C629	Q6_h7	GND	2.557E-17
C630	avI11/avC8_h3	GND	6.564E-17
C631	avI11/avC9_h7	GND	6.972E-17
C632	avI11/avC9_h5	GND	1.236E-16
C633	avC1_11_h9	GND	2.621E-17
C634	Q7_h7	GND	3.747E-17
C635	Q5_h18	GND	8.451E-17
C636	avI2/avC6_h6	GND	4.889E-17
C637	Q7_h10	GND	8.672E-17
C638	avI3/avC6_h6	GND	4.889E-17
C639	avI4/avC6_h3	GND	4.633E-17
C640	avC13_h11	GND	7.608E-17
C641	avI4/avC7_h7	GND	4.138E-17
C642	avC1_1_h6	GND	5.116E-17
C643	Q0_h6	GND	1.103E-16
C644	avC1_5_h4	GND	5.152E-17
C645	Q1_h6	GND	1.122E-16
C646	avC1_6_h4	GND	5.151E-17
C647	Q2_h6	GND	1.122E-16
C648	avC1_7_h4	GND	5.061E-17
C649	Q3_h6	GND	1.122E-16
C650	avC1_8_h4	GND	5.152E-17
C651	Q4_h6	GND	1.122E-16
C652	avC1_9_h4	GND	5.152E-17
C653	Q5_h6	GND	1.122E-16
C654	avC1_10_h4	GND	5.061E-17
C655	Q6_h6	GND	1.122E-16
C656	avC1_11_h4	GND	5.223E-17
C657	Q7_h6	GND	1.128E-16
C658	Q5_h25	GND	8.292E-17
C659	Q7_h17	GND	8.997E-17
C660	avI5/avC9_h3	GND	2.684E-16
C661	avI6/avC9_h3	GND	2.687E-16
C662	avI7/avC9_h3	GND	2.687E-16
C663	avI8/avC9_h3	GND	2.687E-16
C664	avI9/avC9_h3	GND	2.687E-16
C665	avI10/avC9_h3	GND	2.658E-16
C666	avI11/avC9_h3	GND	2.820E-16
.ENDS TSPC_LFSR_8bit_RCX
simulator lang=spectre
subckt TSPC_LFSR_8bit CLK RST Q0 Q1 Q2 Q3 Q4 Q5 Q6 Q7 VDD GND
    XR (VDD GND CLK Q0 Q1 Q2 Q3 Q4 Q5 Q6 Q7 RST) TSPC_LFSR_8bit_RCX
ends TSPC_LFSR_8bit
