// LFSR_8bit.scs - loi PRNG 8 bit cua TV4 (Huynh Anh Tuan).
// Da thuc 1 + x + x^6 + x^7 + x^8 (W&H Bang 11.8): dich Q0 -> Q7, D0 = Q0 ^ Q5 ^ Q6 ^ Q7 (XORTAP8 cua TV3).
// Nap seed 0x01 khi RST = 1: FF0 dung chan SET, FF1..FF7 dung chan RST.
// Can: cell TV3 commit 86e42ee (INV_X1 NAND2_X1 NOR2_X1 NOR3_X1 XOR2_X1 XOR2_TG6), XORTAP8/XORTAP8_CMOS, CFSR_FB (ZERO7), cells/cells.scs cua TV4 (INV_CLK, DFF_MS, DFF_TSPC).
// Nguon: VDD, GND (quy uoc nhom, giong TV3).
simulator lang=spectre

// Ban chuan (baseline): 8 x DFF_MS (TV1) + 1 inverter tao CLKB dung chung
subckt MS_LFSR_8bit CLK RST Q0 Q1 Q2 Q3 Q4 Q5 Q6 Q7 VDD GND
    ICKB (CLK CLKB VDD GND) INV_CLK
    IFB (Q0 Q5 Q6 Q7 D0 VDD GND) XORTAP8
    IF0 (D0 CLK CLKB RST GND Q0 VDD GND) DFF_MS
    IF1 (Q0 CLK CLKB GND RST Q1 VDD GND) DFF_MS
    IF2 (Q1 CLK CLKB GND RST Q2 VDD GND) DFF_MS
    IF3 (Q2 CLK CLKB GND RST Q3 VDD GND) DFF_MS
    IF4 (Q3 CLK CLKB GND RST Q4 VDD GND) DFF_MS
    IF5 (Q4 CLK CLKB GND RST Q5 VDD GND) DFF_MS
    IF6 (Q5 CLK CLKB GND RST Q6 VDD GND) DFF_MS
    IF7 (Q6 CLK CLKB GND RST Q7 VDD GND) DFF_MS
ends MS_LFSR_8bit

// Ban de xuat: 8 x DFF_TSPC (TV2), chi 1 pha clock
subckt TSPC_LFSR_8bit CLK RST Q0 Q1 Q2 Q3 Q4 Q5 Q6 Q7 VDD GND
    IFB (Q0 Q5 Q6 Q7 D0 VDD GND) XORTAP8
    IF0 (D0 CLK RST GND Q0 VDD GND) DFF_TSPC
    IF1 (Q0 CLK GND RST Q1 VDD GND) DFF_TSPC
    IF2 (Q1 CLK GND RST Q2 VDD GND) DFF_TSPC
    IF3 (Q2 CLK GND RST Q3 VDD GND) DFF_TSPC
    IF4 (Q3 CLK GND RST Q4 VDD GND) DFF_TSPC
    IF5 (Q4 CLK GND RST Q5 VDD GND) DFF_TSPC
    IF6 (Q5 CLK GND RST Q6 VDD GND) DFF_TSPC
    IF7 (Q6 CLK GND RST Q7 VDD GND) DFF_TSPC
ends TSPC_LFSR_8bit

// Ban doi chung: mang hoi tiep 3 XOR CMOS 12T (XORTAP8_CMOS cua TV3, 36T) - de so sanh voi XORTAP8 (24T)
subckt TSPC_LFSR_8bit_CMOS CLK RST Q0 Q1 Q2 Q3 Q4 Q5 Q6 Q7 VDD GND
    IFB (Q0 Q5 Q6 Q7 D0 VDD GND) XORTAP8_CMOS
    IF0 (D0 CLK RST GND Q0 VDD GND) DFF_TSPC
    IF1 (Q0 CLK GND RST Q1 VDD GND) DFF_TSPC
    IF2 (Q1 CLK GND RST Q2 VDD GND) DFF_TSPC
    IF3 (Q2 CLK GND RST Q3 VDD GND) DFF_TSPC
    IF4 (Q3 CLK GND RST Q4 VDD GND) DFF_TSPC
    IF5 (Q4 CLK GND RST Q5 VDD GND) DFF_TSPC
    IF6 (Q5 CLK GND RST Q6 VDD GND) DFF_TSPC
    IF7 (Q6 CLK GND RST Q7 VDD GND) DFF_TSPC
ends TSPC_LFSR_8bit_CMOS

// CFSR 256 trang thai (CFSR_FB cua TV3): reset ve 00000000, khong can seed
subckt TSPC_CFSR_8bit CLK RST Q0 Q1 Q2 Q3 Q4 Q5 Q6 Q7 VDD GND
    IFB (Q0 Q1 Q2 Q3 Q4 Q5 Q6 Q7 D0 VDD GND) CFSR_FB
    IF0 (D0 CLK GND RST Q0 VDD GND) DFF_TSPC
    IF1 (Q0 CLK GND RST Q1 VDD GND) DFF_TSPC
    IF2 (Q1 CLK GND RST Q2 VDD GND) DFF_TSPC
    IF3 (Q2 CLK GND RST Q3 VDD GND) DFF_TSPC
    IF4 (Q3 CLK GND RST Q4 VDD GND) DFF_TSPC
    IF5 (Q4 CLK GND RST Q5 VDD GND) DFF_TSPC
    IF6 (Q5 CLK GND RST Q6 VDD GND) DFF_TSPC
    IF7 (Q6 CLK GND RST Q7 VDD GND) DFF_TSPC
ends TSPC_CFSR_8bit
