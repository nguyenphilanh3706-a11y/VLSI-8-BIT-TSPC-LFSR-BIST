// LFSR_8bit.scs - loi PRNG 8 bit cua TV4 (Huynh Anh Tuan).
// Da thuc 1 + x + x^6 + x^7 + x^8 (W&H Bang 11.8): dich Q0 -> Q7, D0 = Q0 ^ Q5 ^ Q6 ^ Q7 (XORTAP8 cua TV3).
// Nap seed 0x01 khi RST = 1: FF0 la TSPC_DFF_S (SET = RST), FF1..FF7 la TSPC_DFF_R (flip-flop TSPC cua TV2, depend/tv2).
// Ban MS van dung flip-flop tam DFF_MS_TMP (qua DFF_MS) cho den khi TV1 nop cell. QB cua cell TV2 de ho (nut dong).
// Can: cell TV3 commit 435f6f0 (INV_X1 NAND2_X1 NOR2_X1 NOR3_X1 XOR2_X1 XOR2_TG6 AOI21_X1 XNOR2_X1), XORTAP8/XORTAP8_CMOS, CFSR_FB_OPT, cells/cells.scs cua TV4 (INV_CLK, DFF_MS), depend/tv2 (TSPC_DFF_R, TSPC_DFF_S commit 25fc686).
// Nguon: VDD, GND (quy uoc nhom, giong TV3).
simulator lang=spectre

// Ban chuan (baseline): 8 x DFF_MS (TV1) + 1 inverter tao CLKB dung chung
subckt MS_LFSR_8bit CLK RST Q0 Q1 Q2 Q3 Q4 Q5 Q6 Q7 VDD GND
    ICKB (CLK CLKB VDD GND) INV_CLK
    IFB (Q0 Q5 Q6 Q7 D0 VDD GND) XORTAP8
    IF0 (D0 CLK CLKB RST GND Q0 VDD GND) DFF_MS
    IF1 (Q0 CLK CLKB GND RST Q1 VDD GND) DFF_MS
    IF2 (Q1 CLK CLKB GND RST Q2 VDD GND) DFF_MS
    IF3 (Q2 CLK CLKB GND RST Q3 VDD GND) DFF_MS
    IF4 (Q3 CLK CLKB GND RST Q4 VDD GND) DFF_MS
    IF5 (Q4 CLK CLKB GND RST Q5 VDD GND) DFF_MS
    IF6 (Q5 CLK CLKB GND RST Q6 VDD GND) DFF_MS
    IF7 (Q6 CLK CLKB GND RST Q7 VDD GND) DFF_MS
ends MS_LFSR_8bit

// Ban de xuat: 8 flip-flop TSPC cua TV2 (1 TSPC_DFF_S + 7 TSPC_DFF_R), chi 1 pha clock
subckt TSPC_LFSR_8bit CLK RST Q0 Q1 Q2 Q3 Q4 Q5 Q6 Q7 VDD GND
    IFB (Q0 Q5 Q6 Q7 D0 VDD GND) XORTAP8
    IF0 (D0 CLK RST Q0 qb_F0 VDD GND) TSPC_DFF_S
    IF1 (Q0 CLK RST Q1 qb_F1 VDD GND) TSPC_DFF_R
    IF2 (Q1 CLK RST Q2 qb_F2 VDD GND) TSPC_DFF_R
    IF3 (Q2 CLK RST Q3 qb_F3 VDD GND) TSPC_DFF_R
    IF4 (Q3 CLK RST Q4 qb_F4 VDD GND) TSPC_DFF_R
    IF5 (Q4 CLK RST Q5 qb_F5 VDD GND) TSPC_DFF_R
    IF6 (Q5 CLK RST Q6 qb_F6 VDD GND) TSPC_DFF_R
    IF7 (Q6 CLK RST Q7 qb_F7 VDD GND) TSPC_DFF_R
ends TSPC_LFSR_8bit

// Ban doi chung: mang hoi tiep 3 XOR CMOS 12T (XORTAP8_CMOS cua TV3, 36T) - de so sanh voi XORTAP8 (24T)
subckt TSPC_LFSR_8bit_CMOS CLK RST Q0 Q1 Q2 Q3 Q4 Q5 Q6 Q7 VDD GND
    IFB (Q0 Q5 Q6 Q7 D0 VDD GND) XORTAP8_CMOS
    IF0 (D0 CLK RST Q0 qb_F0 VDD GND) TSPC_DFF_S
    IF1 (Q0 CLK RST Q1 qb_F1 VDD GND) TSPC_DFF_R
    IF2 (Q1 CLK RST Q2 qb_F2 VDD GND) TSPC_DFF_R
    IF3 (Q2 CLK RST Q3 qb_F3 VDD GND) TSPC_DFF_R
    IF4 (Q3 CLK RST Q4 qb_F4 VDD GND) TSPC_DFF_R
    IF5 (Q4 CLK RST Q5 qb_F5 VDD GND) TSPC_DFF_R
    IF6 (Q5 CLK RST Q6 qb_F6 VDD GND) TSPC_DFF_R
    IF7 (Q6 CLK RST Q7 qb_F7 VDD GND) TSPC_DFF_R
ends TSPC_LFSR_8bit_CMOS

// CFSR 256 trang thai (CFSR_FB_OPT 42T cua TV3, ban toi uu cua CFSR_FB 56T): reset ve 00000000, khong can seed
subckt TSPC_CFSR_8bit CLK RST Q0 Q1 Q2 Q3 Q4 Q5 Q6 Q7 VDD GND
    IFB (Q0 Q1 Q2 Q3 Q4 Q5 Q6 Q7 D0 VDD GND) CFSR_FB_OPT
    IF0 (D0 CLK RST Q0 qb_F0 VDD GND) TSPC_DFF_R
    IF1 (Q0 CLK RST Q1 qb_F1 VDD GND) TSPC_DFF_R
    IF2 (Q1 CLK RST Q2 qb_F2 VDD GND) TSPC_DFF_R
    IF3 (Q2 CLK RST Q3 qb_F3 VDD GND) TSPC_DFF_R
    IF4 (Q3 CLK RST Q4 qb_F4 VDD GND) TSPC_DFF_R
    IF5 (Q4 CLK RST Q5 qb_F5 VDD GND) TSPC_DFF_R
    IF6 (Q5 CLK RST Q6 qb_F6 VDD GND) TSPC_DFF_R
    IF7 (Q6 CLK RST Q7 qb_F7 VDD GND) TSPC_DFF_R
ends TSPC_CFSR_8bit
