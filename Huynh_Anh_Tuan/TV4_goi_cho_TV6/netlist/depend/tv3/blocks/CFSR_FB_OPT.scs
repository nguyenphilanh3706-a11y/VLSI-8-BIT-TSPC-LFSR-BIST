// CFSR_FB_OPT: ban toi uu cua CFSR_FB, cung ham FB = Q0 ^ Q5 ^ Q6 ^ Q7 ^ NOR(Q0..Q6), 42 transistor.
// Z = NOR(Q0..Q6) = 1 thi Q0 = Q5 = Q6 = 0 nen (Q0 ^ Q5) va Z khong dong thoi bang 1: (Q0 ^ Q5) ^ Z = (Q0 ^ Q5) | Z.
// Khi Q0 ^ Q5 = 0 va Q0 = 0 thi Q5 = 0, nen Z chi can xet Q0 Q1 Q2 Q3 Q4 Q6:
//   FB = (Q6 ^ Q7) ^ W,  W = (Q0 ^ Q5) | NOR3(Q0,Q1,Q2) & NOR3(Q3,Q4,Q6)
// !W lay tu mot cong AOI21, tang cuoi la XNOR CMOS (phuc hoi muc logic, lai ngo D).
simulator lang=spectre
subckt CFSR_FB_OPT Q0 Q1 Q2 Q3 Q4 Q5 Q6 Q7 FB VDD GND
I0 (Q0 Q5 t05 VDD GND) XOR2_TG6
I1 (Q6 Q7 t67 VDD GND) XOR2_TG6
I2 (Q0 Q1 Q2 n012 VDD GND) NOR3_X1
I3 (Q3 Q4 Q6 n346 VDD GND) NOR3_X1
I4 (n012 n346 t05 wn VDD GND) AOI21_X1
I5 (t67 wn FB VDD GND) XNOR2_X1
ends CFSR_FB_OPT
