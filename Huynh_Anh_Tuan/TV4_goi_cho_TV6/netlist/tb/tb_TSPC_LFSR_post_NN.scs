// tb_TSPC_LFSR_post, corner NN
simulator lang=spectre
include "/home/buet/cadence/gpdk090_v4.6/models/spectre/gpdk090.scs" section=NN
include "../depend/tv3/cells/cells.scs"
include "../cells/cells.scs"
include "../layout/rcx/TSPC_LFSR_8bit_post.scs"
include "tb_TSPC_LFSR_post.scs"
