// INV_CLK - cong phu tro cua TV4 (gpdk090, 1.2 V), dung cell TV3 (INV_X1, NAND2_X1).
simulator lang=spectre
// Inverter lon de dem clock / tao CLKB cho 8 flip-flop (gap 4 lan INV_X1)
subckt INV_CLK A Y VDD GND
    MN0 (Y A GND GND) gpdk090_nmos1v w=0.48u l=0.1u
    MP0 (Y A VDD VDD) gpdk090_pmos1v w=0.96u l=0.1u
ends INV_CLK
