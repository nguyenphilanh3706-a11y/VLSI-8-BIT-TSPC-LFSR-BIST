// tb_TSPC_LFSR_asad_slew (TV2 co as/ad), corner NN
simulator lang=spectre
include "/home/buet/cadence/gpdk090_v4.6/models/spectre/gpdk090.scs" section=NN
include "../depend/tv3/cells/cells.scs"
include "../depend/tv3/blocks/XORTAP8.scs"
include "../depend/tv3/blocks/CFSR_FB_OPT.scs"
include "../depend/tv2/cells_asad/cells.scs"
include "../cells/cells.scs"
include "../blocks/LFSR_8bit.scs"
include "../blocks/LT_RTPG_8bit.scs"
include "tb_TSPC_LFSR_asad_slew.scs"
