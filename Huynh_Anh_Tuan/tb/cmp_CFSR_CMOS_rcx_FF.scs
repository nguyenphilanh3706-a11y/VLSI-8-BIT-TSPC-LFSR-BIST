// cmp_CFSR_CMOS_rcx, corner FF
simulator lang=spectre
include "/home/buet/cadence/gpdk090_v4.6/models/spectre/gpdk090.scs" section=FF
include "../depend/tv3/cells/cells.scs"
include "../depend/tv3/blocks/XORTAP8.scs"
include "../depend/tv3/layout/rcx/CFSR_FB_CMOS_rcx.scs"
include "../depend/tv3/blocks/CFSR_FB_OPT.scs"
include "../depend/tv2/cells/cells.scs"
include "../cells/cells.scs"
include "../blocks/LFSR_8bit.scs"
include "../blocks/LT_RTPG_8bit.scs"
include "cmp_CFSR_CMOS_rcx.scs"
