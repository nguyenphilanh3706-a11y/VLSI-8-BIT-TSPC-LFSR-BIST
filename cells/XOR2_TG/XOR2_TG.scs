// Y = A ^ B.  Pins: A B Y VDD VSS.  Transmission gate, 8 transistors:
// 2 input inverters + 2 TG: A=0 truyen B, A=1 truyen !B.
simulator lang=spectre
subckt XOR2_TG A B Y VDD VSS
    MN0 (An A VSS VSS) gpdk090_nmos1v w=0.12u l=0.1u
    MP0 (An A VDD VDD) gpdk090_pmos1v w=0.24u l=0.1u
    MN1 (Bn B VSS VSS) gpdk090_nmos1v w=0.12u l=0.1u
    MP1 (Bn B VDD VDD) gpdk090_pmos1v w=0.24u l=0.1u
    MN2 (Y An B VSS) gpdk090_nmos1v w=0.24u l=0.1u
    MP2 (Y A B VDD) gpdk090_pmos1v w=0.48u l=0.1u
    MN3 (Y A Bn VSS) gpdk090_nmos1v w=0.24u l=0.1u
    MP3 (Y An Bn VDD) gpdk090_pmos1v w=0.48u l=0.1u
ends XOR2_TG
