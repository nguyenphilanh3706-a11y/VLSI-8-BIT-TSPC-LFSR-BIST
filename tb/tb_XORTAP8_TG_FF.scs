// XORTAP8_TG, corner FF
simulator lang=spectre
include "/home/buet/cadence/gpdk090_v4.6/models/spectre/gpdk090.scs" section=FF
include "../cells/cells.scs"
include "../cells/XOR2_TG/XOR2_TG.scs"
include "../blocks/XORTAP8.scs"
include "tb_XORTAP8_TG.scs"
