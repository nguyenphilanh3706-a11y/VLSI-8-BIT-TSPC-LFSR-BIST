// CFSR_FB: 256 to hop ngo vao, 2 ns/vector, suon 20 ps, tai 4x INV_X1
simulator lang=spectre
global 0
VVDD (VDD 0) vsource dc=1.2
VVSS (VSS 0) vsource dc=0
VQ0 (Q0 0) vsource type=pwl wave=[ 0 0 2000p 0 2020p 1.2 4000p 1.2 4020p 0 6000p 0 6020p 1.2 8000p 1.2 8020p 0 10000p 0 10020p 1.2 12000p 1.2 12020p 0 14000p 0 14020p 1.2 16000p 1.2 16020p 0 18000p 0 18020p 1.2 20000p 1.2 20020p 0 22000p 0 22020p 1.2 24000p 1.2 24020p 0 26000p 0 26020p 1.2 28000p 1.2 28020p 0 30000p 0 30020p 1.2 32000p 1.2 32020p 0 34000p 0 34020p 1.2 36000p 1.2 36020p 0 38000p 0 38020p 1.2 40000p 1.2 40020p 0 42000p 0 42020p 1.2 44000p 1.2 44020p 0 46000p 0 46020p 1.2 48000p 1.2 48020p 0 50000p 0 50020p 1.2 52000p 1.2 52020p 0 54000p 0 54020p 1.2 56000p 1.2 56020p 0 58000p 0 58020p 1.2 60000p 1.2 60020p 0 62000p 0 62020p 1.2 64000p 1.2 64020p 0 66000p 0 66020p 1.2 68000p 1.2 68020p 0 70000p 0 70020p 1.2 72000p 1.2 72020p 0 74000p 0 74020p 1.2 76000p 1.2 76020p 0 78000p 0 78020p 1.2 80000p 1.2 80020p 0 82000p 0 82020p 1.2 84000p 1.2 84020p 0 86000p 0 86020p 1.2 88000p 1.2 88020p 0 90000p 0 90020p 1.2 92000p 1.2 92020p 0 94000p 0 94020p 1.2 96000p 1.2 96020p 0 98000p 0 98020p 1.2 100000p 1.2 100020p 0 102000p 0 102020p 1.2 104000p 1.2 104020p 0 106000p 0 106020p 1.2 108000p 1.2 108020p 0 110000p 0 110020p 1.2 112000p 1.2 112020p 0 114000p 0 114020p 1.2 116000p 1.2 116020p 0 118000p 0 118020p 1.2 120000p 1.2 120020p 0 122000p 0 122020p 1.2 124000p 1.2 124020p 0 126000p 0 126020p 1.2 128000p 1.2 128020p 0 130000p 0 130020p 1.2 132000p 1.2 132020p 0 134000p 0 134020p 1.2 136000p 1.2 136020p 0 138000p 0 138020p 1.2 140000p 1.2 140020p 0 142000p 0 142020p 1.2 144000p 1.2 144020p 0 146000p 0 146020p 1.2 148000p 1.2 148020p 0 150000p 0 150020p 1.2 152000p 1.2 152020p 0 154000p 0 154020p 1.2 156000p 1.2 156020p 0 158000p 0 158020p 1.2 160000p 1.2 160020p 0 162000p 0 162020p 1.2 164000p 1.2 164020p 0 166000p 0 166020p 1.2 168000p 1.2 168020p 0 170000p 0 170020p 1.2 172000p 1.2 172020p 0 174000p 0 174020p 1.2 176000p 1.2 176020p 0 178000p 0 178020p 1.2 180000p 1.2 180020p 0 182000p 0 182020p 1.2 184000p 1.2 184020p 0 186000p 0 186020p 1.2 188000p 1.2 188020p 0 190000p 0 190020p 1.2 192000p 1.2 192020p 0 194000p 0 194020p 1.2 196000p 1.2 196020p 0 198000p 0 198020p 1.2 200000p 1.2 200020p 0 202000p 0 202020p 1.2 204000p 1.2 204020p 0 206000p 0 206020p 1.2 208000p 1.2 208020p 0 210000p 0 210020p 1.2 212000p 1.2 212020p 0 214000p 0 214020p 1.2 216000p 1.2 216020p 0 218000p 0 218020p 1.2 220000p 1.2 220020p 0 222000p 0 222020p 1.2 224000p 1.2 224020p 0 226000p 0 226020p 1.2 228000p 1.2 228020p 0 230000p 0 230020p 1.2 232000p 1.2 232020p 0 234000p 0 234020p 1.2 236000p 1.2 236020p 0 238000p 0 238020p 1.2 240000p 1.2 240020p 0 242000p 0 242020p 1.2 244000p 1.2 244020p 0 246000p 0 246020p 1.2 248000p 1.2 248020p 0 250000p 0 250020p 1.2 252000p 1.2 252020p 0 254000p 0 254020p 1.2 256000p 1.2 256020p 0 258000p 0 258020p 1.2 260000p 1.2 260020p 0 262000p 0 262020p 1.2 264000p 1.2 264020p 0 266000p 0 266020p 1.2 268000p 1.2 268020p 0 270000p 0 270020p 1.2 272000p 1.2 272020p 0 274000p 0 274020p 1.2 276000p 1.2 276020p 0 278000p 0 278020p 1.2 280000p 1.2 280020p 0 282000p 0 282020p 1.2 284000p 1.2 284020p 0 286000p 0 286020p 1.2 288000p 1.2 288020p 0 290000p 0 290020p 1.2 292000p 1.2 292020p 0 294000p 0 294020p 1.2 296000p 1.2 296020p 0 298000p 0 298020p 1.2 300000p 1.2 300020p 0 302000p 0 302020p 1.2 304000p 1.2 304020p 0 306000p 0 306020p 1.2 308000p 1.2 308020p 0 310000p 0 310020p 1.2 312000p 1.2 312020p 0 314000p 0 314020p 1.2 316000p 1.2 316020p 0 318000p 0 318020p 1.2 320000p 1.2 320020p 0 322000p 0 322020p 1.2 324000p 1.2 324020p 0 326000p 0 326020p 1.2 328000p 1.2 328020p 0 330000p 0 330020p 1.2 332000p 1.2 332020p 0 334000p 0 334020p 1.2 336000p 1.2 336020p 0 338000p 0 338020p 1.2 340000p 1.2 340020p 0 342000p 0 342020p 1.2 344000p 1.2 344020p 0 346000p 0 346020p 1.2 348000p 1.2 348020p 0 350000p 0 350020p 1.2 352000p 1.2 352020p 0 354000p 0 354020p 1.2 356000p 1.2 356020p 0 358000p 0 358020p 1.2 360000p 1.2 360020p 0 362000p 0 362020p 1.2 364000p 1.2 364020p 0 366000p 0 366020p 1.2 368000p 1.2 368020p 0 370000p 0 370020p 1.2 372000p 1.2 372020p 0 374000p 0 374020p 1.2 376000p 1.2 376020p 0 378000p 0 378020p 1.2 380000p 1.2 380020p 0 382000p 0 382020p 1.2 384000p 1.2 384020p 0 386000p 0 386020p 1.2 388000p 1.2 388020p 0 390000p 0 390020p 1.2 392000p 1.2 392020p 0 394000p 0 394020p 1.2 396000p 1.2 396020p 0 398000p 0 398020p 1.2 400000p 1.2 400020p 0 402000p 0 402020p 1.2 404000p 1.2 404020p 0 406000p 0 406020p 1.2 408000p 1.2 408020p 0 410000p 0 410020p 1.2 412000p 1.2 412020p 0 414000p 0 414020p 1.2 416000p 1.2 416020p 0 418000p 0 418020p 1.2 420000p 1.2 420020p 0 422000p 0 422020p 1.2 424000p 1.2 424020p 0 426000p 0 426020p 1.2 428000p 1.2 428020p 0 430000p 0 430020p 1.2 432000p 1.2 432020p 0 434000p 0 434020p 1.2 436000p 1.2 436020p 0 438000p 0 438020p 1.2 440000p 1.2 440020p 0 442000p 0 442020p 1.2 444000p 1.2 444020p 0 446000p 0 446020p 1.2 448000p 1.2 448020p 0 450000p 0 450020p 1.2 452000p 1.2 452020p 0 454000p 0 454020p 1.2 456000p 1.2 456020p 0 458000p 0 458020p 1.2 460000p 1.2 460020p 0 462000p 0 462020p 1.2 464000p 1.2 464020p 0 466000p 0 466020p 1.2 468000p 1.2 468020p 0 470000p 0 470020p 1.2 472000p 1.2 472020p 0 474000p 0 474020p 1.2 476000p 1.2 476020p 0 478000p 0 478020p 1.2 480000p 1.2 480020p 0 482000p 0 482020p 1.2 484000p 1.2 484020p 0 486000p 0 486020p 1.2 488000p 1.2 488020p 0 490000p 0 490020p 1.2 492000p 1.2 492020p 0 494000p 0 494020p 1.2 496000p 1.2 496020p 0 498000p 0 498020p 1.2 500000p 1.2 500020p 0 502000p 0 502020p 1.2 504000p 1.2 504020p 0 506000p 0 506020p 1.2 508000p 1.2 508020p 0 510000p 0 510020p 1.2 ]
VQ1 (Q1 0) vsource type=pwl wave=[ 0 0 4000p 0 4020p 1.2 8000p 1.2 8020p 0 12000p 0 12020p 1.2 16000p 1.2 16020p 0 20000p 0 20020p 1.2 24000p 1.2 24020p 0 28000p 0 28020p 1.2 32000p 1.2 32020p 0 36000p 0 36020p 1.2 40000p 1.2 40020p 0 44000p 0 44020p 1.2 48000p 1.2 48020p 0 52000p 0 52020p 1.2 56000p 1.2 56020p 0 60000p 0 60020p 1.2 64000p 1.2 64020p 0 68000p 0 68020p 1.2 72000p 1.2 72020p 0 76000p 0 76020p 1.2 80000p 1.2 80020p 0 84000p 0 84020p 1.2 88000p 1.2 88020p 0 92000p 0 92020p 1.2 96000p 1.2 96020p 0 100000p 0 100020p 1.2 104000p 1.2 104020p 0 108000p 0 108020p 1.2 112000p 1.2 112020p 0 116000p 0 116020p 1.2 120000p 1.2 120020p 0 124000p 0 124020p 1.2 128000p 1.2 128020p 0 132000p 0 132020p 1.2 136000p 1.2 136020p 0 140000p 0 140020p 1.2 144000p 1.2 144020p 0 148000p 0 148020p 1.2 152000p 1.2 152020p 0 156000p 0 156020p 1.2 160000p 1.2 160020p 0 164000p 0 164020p 1.2 168000p 1.2 168020p 0 172000p 0 172020p 1.2 176000p 1.2 176020p 0 180000p 0 180020p 1.2 184000p 1.2 184020p 0 188000p 0 188020p 1.2 192000p 1.2 192020p 0 196000p 0 196020p 1.2 200000p 1.2 200020p 0 204000p 0 204020p 1.2 208000p 1.2 208020p 0 212000p 0 212020p 1.2 216000p 1.2 216020p 0 220000p 0 220020p 1.2 224000p 1.2 224020p 0 228000p 0 228020p 1.2 232000p 1.2 232020p 0 236000p 0 236020p 1.2 240000p 1.2 240020p 0 244000p 0 244020p 1.2 248000p 1.2 248020p 0 252000p 0 252020p 1.2 256000p 1.2 256020p 0 260000p 0 260020p 1.2 264000p 1.2 264020p 0 268000p 0 268020p 1.2 272000p 1.2 272020p 0 276000p 0 276020p 1.2 280000p 1.2 280020p 0 284000p 0 284020p 1.2 288000p 1.2 288020p 0 292000p 0 292020p 1.2 296000p 1.2 296020p 0 300000p 0 300020p 1.2 304000p 1.2 304020p 0 308000p 0 308020p 1.2 312000p 1.2 312020p 0 316000p 0 316020p 1.2 320000p 1.2 320020p 0 324000p 0 324020p 1.2 328000p 1.2 328020p 0 332000p 0 332020p 1.2 336000p 1.2 336020p 0 340000p 0 340020p 1.2 344000p 1.2 344020p 0 348000p 0 348020p 1.2 352000p 1.2 352020p 0 356000p 0 356020p 1.2 360000p 1.2 360020p 0 364000p 0 364020p 1.2 368000p 1.2 368020p 0 372000p 0 372020p 1.2 376000p 1.2 376020p 0 380000p 0 380020p 1.2 384000p 1.2 384020p 0 388000p 0 388020p 1.2 392000p 1.2 392020p 0 396000p 0 396020p 1.2 400000p 1.2 400020p 0 404000p 0 404020p 1.2 408000p 1.2 408020p 0 412000p 0 412020p 1.2 416000p 1.2 416020p 0 420000p 0 420020p 1.2 424000p 1.2 424020p 0 428000p 0 428020p 1.2 432000p 1.2 432020p 0 436000p 0 436020p 1.2 440000p 1.2 440020p 0 444000p 0 444020p 1.2 448000p 1.2 448020p 0 452000p 0 452020p 1.2 456000p 1.2 456020p 0 460000p 0 460020p 1.2 464000p 1.2 464020p 0 468000p 0 468020p 1.2 472000p 1.2 472020p 0 476000p 0 476020p 1.2 480000p 1.2 480020p 0 484000p 0 484020p 1.2 488000p 1.2 488020p 0 492000p 0 492020p 1.2 496000p 1.2 496020p 0 500000p 0 500020p 1.2 504000p 1.2 504020p 0 508000p 0 508020p 1.2 ]
VQ2 (Q2 0) vsource type=pwl wave=[ 0 0 8000p 0 8020p 1.2 16000p 1.2 16020p 0 24000p 0 24020p 1.2 32000p 1.2 32020p 0 40000p 0 40020p 1.2 48000p 1.2 48020p 0 56000p 0 56020p 1.2 64000p 1.2 64020p 0 72000p 0 72020p 1.2 80000p 1.2 80020p 0 88000p 0 88020p 1.2 96000p 1.2 96020p 0 104000p 0 104020p 1.2 112000p 1.2 112020p 0 120000p 0 120020p 1.2 128000p 1.2 128020p 0 136000p 0 136020p 1.2 144000p 1.2 144020p 0 152000p 0 152020p 1.2 160000p 1.2 160020p 0 168000p 0 168020p 1.2 176000p 1.2 176020p 0 184000p 0 184020p 1.2 192000p 1.2 192020p 0 200000p 0 200020p 1.2 208000p 1.2 208020p 0 216000p 0 216020p 1.2 224000p 1.2 224020p 0 232000p 0 232020p 1.2 240000p 1.2 240020p 0 248000p 0 248020p 1.2 256000p 1.2 256020p 0 264000p 0 264020p 1.2 272000p 1.2 272020p 0 280000p 0 280020p 1.2 288000p 1.2 288020p 0 296000p 0 296020p 1.2 304000p 1.2 304020p 0 312000p 0 312020p 1.2 320000p 1.2 320020p 0 328000p 0 328020p 1.2 336000p 1.2 336020p 0 344000p 0 344020p 1.2 352000p 1.2 352020p 0 360000p 0 360020p 1.2 368000p 1.2 368020p 0 376000p 0 376020p 1.2 384000p 1.2 384020p 0 392000p 0 392020p 1.2 400000p 1.2 400020p 0 408000p 0 408020p 1.2 416000p 1.2 416020p 0 424000p 0 424020p 1.2 432000p 1.2 432020p 0 440000p 0 440020p 1.2 448000p 1.2 448020p 0 456000p 0 456020p 1.2 464000p 1.2 464020p 0 472000p 0 472020p 1.2 480000p 1.2 480020p 0 488000p 0 488020p 1.2 496000p 1.2 496020p 0 504000p 0 504020p 1.2 ]
VQ3 (Q3 0) vsource type=pwl wave=[ 0 0 16000p 0 16020p 1.2 32000p 1.2 32020p 0 48000p 0 48020p 1.2 64000p 1.2 64020p 0 80000p 0 80020p 1.2 96000p 1.2 96020p 0 112000p 0 112020p 1.2 128000p 1.2 128020p 0 144000p 0 144020p 1.2 160000p 1.2 160020p 0 176000p 0 176020p 1.2 192000p 1.2 192020p 0 208000p 0 208020p 1.2 224000p 1.2 224020p 0 240000p 0 240020p 1.2 256000p 1.2 256020p 0 272000p 0 272020p 1.2 288000p 1.2 288020p 0 304000p 0 304020p 1.2 320000p 1.2 320020p 0 336000p 0 336020p 1.2 352000p 1.2 352020p 0 368000p 0 368020p 1.2 384000p 1.2 384020p 0 400000p 0 400020p 1.2 416000p 1.2 416020p 0 432000p 0 432020p 1.2 448000p 1.2 448020p 0 464000p 0 464020p 1.2 480000p 1.2 480020p 0 496000p 0 496020p 1.2 ]
VQ4 (Q4 0) vsource type=pwl wave=[ 0 0 32000p 0 32020p 1.2 64000p 1.2 64020p 0 96000p 0 96020p 1.2 128000p 1.2 128020p 0 160000p 0 160020p 1.2 192000p 1.2 192020p 0 224000p 0 224020p 1.2 256000p 1.2 256020p 0 288000p 0 288020p 1.2 320000p 1.2 320020p 0 352000p 0 352020p 1.2 384000p 1.2 384020p 0 416000p 0 416020p 1.2 448000p 1.2 448020p 0 480000p 0 480020p 1.2 ]
VQ5 (Q5 0) vsource type=pwl wave=[ 0 0 64000p 0 64020p 1.2 128000p 1.2 128020p 0 192000p 0 192020p 1.2 256000p 1.2 256020p 0 320000p 0 320020p 1.2 384000p 1.2 384020p 0 448000p 0 448020p 1.2 ]
VQ6 (Q6 0) vsource type=pwl wave=[ 0 0 128000p 0 128020p 1.2 256000p 1.2 256020p 0 384000p 0 384020p 1.2 ]
VQ7 (Q7 0) vsource type=pwl wave=[ 0 0 256000p 0 256020p 1.2 ]
XDUT (Q0 Q1 Q2 Q3 Q4 Q5 Q6 Q7 FB VDD VSS) CFSR_FB
XL_FB_0 (FB ld0 VDD VSS) INV_X1
XL_FB_1 (FB ld1 VDD VSS) INV_X1
XL_FB_2 (FB ld2 VDD VSS) INV_X1
XL_FB_3 (FB ld3 VDD VSS) INV_X1
save Q0 Q1 Q2 Q3 Q4 Q5 Q6 Q7 FB VVDD:p
opts options save=selected temp=27 reltol=1e-3
tran tran stop=512n maxstep=20p errpreset=moderate
